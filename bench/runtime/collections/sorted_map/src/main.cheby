//! Runtime benchmark of the collections group: `std::sorted_map` (D-664).
//!
//! Pseudo-random keys go into a sorted map, each with its step number as
//! the value. The same keys are looked up again, every other one is
//! removed, the entries with even values are kept by `filter`, a range of
//! keys is listed and the kept entries are folded. Only the loop holds
//! the map while it changes, so each insert and remove can rebuild its
//! path in place. The number of keys is the first program argument, and
//! `main` prints a checksum that `bench/baselines` computes too.

import std::env
import std::int
import std::io
import std::list
import std::sorted_map
import std::sorted_map::{SortedMap}

/// The number of keys when no argument is given.
const default_size: Int = 600_000

/// Keys are drawn below this bound.
const key_space: Int = 1_000_000

/// Keeps the checksum small.
const modulus: Int = 1_000_000_007

fn main() {
  let n = size(env::args())
  let built = build(sorted_map::new(), 0, n, 42)
  let looked = look(built, n, 42, 0)
  let thinned = thin(built, n / 2, 42)
  let evens = sorted_map::filter(thinned, fn(_, value) { value % 2 == 0 })
  let summed = sorted_map::fold(evens, 0, fn(total, key, value) {
    (total + key * 7 + value) % modulus
  })
  let ranged = list::length(sorted_map::range(thinned, 250_000, 260_000))
  let checksum = mix(mix(mix(mix(0, looked), sorted_map::size(thinned)), summed), ranged)
  io::println("size: {n}")
  io::println("checksum: {checksum}")
}

/// The size from the first program argument, or `default_size`.
fn size(args: List<String>) -> Int {
  case args {
    [] => default_size
    [first, ..] => {
      let assert Ok(n) = int::parse(first)
      n
    }
  }
}

/// The pseudo-random number after `seed`, from a linear congruential
/// generator.
fn next(seed: Int) -> Int {
  (seed * 1_103_515_245 + 12_345) % 2_147_483_648
}

/// Adds `n` to the checksum `total`.
fn mix(total: Int, n: Int) -> Int {
  (total * 31 + n) % modulus
}

/// `m` with the keys of steps `i` to `n` of the sequence from `seed`, each
/// stored with its step.
fn build(m: SortedMap<Int, Int>, i: Int, n: Int, seed: Int) -> SortedMap<Int, Int> {
  case i == n {
    True => m
    False => build(sorted_map::insert(m, seed % key_space, i), i + 1, n, next(seed))
  }
}

/// Adds to `total` the value of each of `count` keys of the sequence from
/// `seed`, or 1 for a key that is missing.
fn look(m: SortedMap<Int, Int>, count: Int, seed: Int, total: Int) -> Int {
  case count {
    0 => total
    _ => {
      let found = case sorted_map::get(m, seed % key_space) {
        Some(value) => value
        None => 1
      }
      look(m, count - 1, next(seed), (total + found) % modulus)
    }
  }
}

/// `m` without `count` keys: every other key of the sequence from `seed`.
fn thin(m: SortedMap<Int, Int>, count: Int, seed: Int) -> SortedMap<Int, Int> {
  case count {
    0 => m
    _ => thin(sorted_map::remove(m, seed % key_space), count - 1, next(next(seed)))
  }
}
