//! The built-in `U16`, a unsigned 16-bit integer: constants, conversions,
//! parsing and text, comparison, and checked and wrapping arithmetic
//! (the integer families of `docs/stdlib/README.md`, D-350).
//!
//! `U16` itself is a builtin item whose home module is this one (D-447).

import std::int

// Constants

/// The smallest `U16`.
pub const min_value: U16 = 0

/// The largest `U16`.
pub const max_value: U16 = 65_535

// Conversions

/// Returns `n` as an `U16`, or `Err(Nil)` when it does not fit.
@external(native, "cheby_u16_from_int")
@external(js, "./u16.mjs", "from_int")
pub fn from_int(n: Int) -> Result<U16, Nil>

/// Returns `n` as an `U16`, or `Err(Nil)` when it does not fit.
@external(native, "cheby_u16_from_i8")
@external(js, "./u16.mjs", "from_i8")
pub fn from_i8(n: I8) -> Result<U16, Nil>

/// Returns `n` as an `U16`, or `Err(Nil)` when it does not fit.
@external(native, "cheby_u16_from_i16")
@external(js, "./u16.mjs", "from_i16")
pub fn from_i16(n: I16) -> Result<U16, Nil>

/// Returns `n` as an `U16`, or `Err(Nil)` when it does not fit.
@external(native, "cheby_u16_from_i32")
@external(js, "./u16.mjs", "from_i32")
pub fn from_i32(n: I32) -> Result<U16, Nil>

/// Returns `n` as an `U16`, or `Err(Nil)` when it does not fit.
@external(native, "cheby_u16_from_i64")
@external(js, "./u16.mjs", "from_i64")
pub fn from_i64(n: I64) -> Result<U16, Nil>

/// Returns `n` as an `U16`. Every `U8` fits.
@external(native, "cheby_u16_from_u8")
@external(js, "./u16.mjs", "from_u8")
pub fn from_u8(n: U8) -> U16

/// Returns `n` as an `U16`, or `Err(Nil)` when it does not fit.
@external(native, "cheby_u16_from_u32")
@external(js, "./u16.mjs", "from_u32")
pub fn from_u32(n: U32) -> Result<U16, Nil>

/// Returns `n` as an `U16`, or `Err(Nil)` when it does not fit.
@external(native, "cheby_u16_from_u64")
@external(js, "./u16.mjs", "from_u64")
pub fn from_u64(n: U64) -> Result<U16, Nil>

/// Keeps the low 16 bits of `n`'s two's-complement value and reads them as a `U16` (D-1091).
pub fn wrapping_from_int(n: Int) -> U16 {
  let assert Ok(low) = from_int(n & 0xFFFF)
  low
}

/// Keeps the low 16 bits of `n`'s two's-complement value and reads them as a `U16` (D-1091).
pub fn wrapping_from_i8(n: I8) -> U16 {
  case n >= 0 {
    True => {
      let assert Ok(value) = from_i8(n)
      value
    }
    False => {
      // `-(n + 1)` fits, and `max_value` minus it is 2^16 + n.
      let assert Ok(complement) = from_i8(-(n + 1))
      max_value - complement
    }
  }
}

/// Keeps the low 16 bits of `n`'s two's-complement value and reads them as a `U16` (D-1091).
pub fn wrapping_from_i16(n: I16) -> U16 {
  case n >= 0 {
    True => {
      let assert Ok(value) = from_i16(n)
      value
    }
    False => {
      // `-(n + 1)` fits, and `max_value` minus it is 2^16 + n.
      let assert Ok(complement) = from_i16(-(n + 1))
      max_value - complement
    }
  }
}

/// Keeps the low 16 bits of `n`'s two's-complement value and reads them as a `U16` (D-1091).
pub fn wrapping_from_i32(n: I32) -> U16 {
  let assert Ok(low) = from_i32(n & 0xFFFF)
  low
}

/// Keeps the low 16 bits of `n`'s two's-complement value and reads them as a `U16` (D-1091).
pub fn wrapping_from_i64(n: I64) -> U16 {
  let assert Ok(low) = from_i64(n & 0xFFFF)
  low
}

/// Keeps the low 16 bits of `n`'s two's-complement value and reads them as a `U16` (D-1091).
pub fn wrapping_from_u32(n: U32) -> U16 {
  let assert Ok(low) = from_u32(n & 0xFFFF)
  low
}

/// Keeps the low 16 bits of `n`'s two's-complement value and reads them as a `U16` (D-1091).
pub fn wrapping_from_u64(n: U64) -> U16 {
  let assert Ok(low) = from_u64(n & 0xFFFF)
  low
}

test "wrapping_from keeps the low 16 bits of every source" {
  assert wrapping_from_int(-1) == 65_535
  assert wrapping_from_int(0) == 0
  assert wrapping_from_int(1) == 1
  assert wrapping_from_int(65_535) == 65_535
  assert wrapping_from_int(65_536) == 0
  assert wrapping_from_i8(-128) == 65_408
  assert wrapping_from_i8(-17) == 65_519
  assert wrapping_from_i8(-1) == 65_535
  assert wrapping_from_i8(0) == 0
  assert wrapping_from_i8(1) == 1
  assert wrapping_from_i8(17) == 17
  assert wrapping_from_i8(127) == 127
  assert wrapping_from_i16(-32_768) == 32_768
  assert wrapping_from_i16(-12_817) == 52_719
  assert wrapping_from_i16(-1) == 65_535
  assert wrapping_from_i16(0) == 0
  assert wrapping_from_i16(1) == 1
  assert wrapping_from_i16(12_817) == 12_817
  assert wrapping_from_i16(32_767) == 32_767
  assert wrapping_from_i32(-2_147_483_648) == 0
  assert wrapping_from_i32(-1_985_229_329) == 52_719
  assert wrapping_from_i32(-1) == 65_535
  assert wrapping_from_i32(0) == 0
  assert wrapping_from_i32(1) == 1
  assert wrapping_from_i32(65_535) == 65_535
  assert wrapping_from_i32(65_536) == 0
  assert wrapping_from_i32(1_985_229_329) == 12_817
  assert wrapping_from_i32(2_147_483_647) == 65_535
  assert wrapping_from_i64(-9_223_372_036_854_775_808) == 0
  assert wrapping_from_i64(-81_985_529_216_486_895) == 12_817
  assert wrapping_from_i64(-1) == 65_535
  assert wrapping_from_i64(0) == 0
  assert wrapping_from_i64(1) == 1
  assert wrapping_from_i64(65_535) == 65_535
  assert wrapping_from_i64(65_536) == 0
  assert wrapping_from_i64(81_985_529_216_486_895) == 52_719
  assert wrapping_from_i64(9_223_372_036_854_775_807) == 65_535
  assert wrapping_from_u32(0) == 0
  assert wrapping_from_u32(1) == 1
  assert wrapping_from_u32(65_535) == 65_535
  assert wrapping_from_u32(65_536) == 0
  assert wrapping_from_u32(2_309_737_967) == 52_719
  assert wrapping_from_u32(4_294_967_295) == 65_535
  assert wrapping_from_u64(0) == 0
  assert wrapping_from_u64(1) == 1
  assert wrapping_from_u64(65_535) == 65_535
  assert wrapping_from_u64(65_536) == 0
  assert wrapping_from_u64(81_985_529_216_486_895) == 52_719
  assert wrapping_from_u64(18_446_744_073_709_551_615) == 65_535
}

@target(native)
test "wrapping_from_int keeps the low 16 bits of every Int" {
  assert wrapping_from_int(-9_223_372_036_854_775_808) == 0
  assert wrapping_from_int(-81_985_529_216_486_895) == 12_817
  assert wrapping_from_int(81_985_529_216_486_895) == 52_719
  assert wrapping_from_int(9_223_372_036_854_775_807) == 65_535
}

// Parsing and text

/// Reads an `U16` written as an optional `-` and ASCII decimal digits (D-312).
@external(native, "cheby_u16_parse")
@external(js, "./u16.mjs", "parse")
pub fn parse(text: String) -> Result<U16, Nil>

/// Reads an `U16` written in `base`, from 2 to 36, as an optional `-` and digits.
@external(native, "cheby_u16_parse_base")
@external(js, "./u16.mjs", "parse_base")
pub fn parse_base(text: String, base: Int) -> Result<U16, Nil>

/// Returns `n` written in `base`, from 2 to 36, in lowercase digits (D-390, D-1090).
pub fn to_base(n: U16, base: Int) -> Result<String, Nil> {
  int::to_base(int::from_u16(n), base)
}

test "to_base writes every U16 in every base" {
  assert to_base(0, 2) == Ok("0")
  assert to_base(0, 8) == Ok("0")
  assert to_base(0, 10) == Ok("0")
  assert to_base(0, 16) == Ok("0")
  assert to_base(0, 36) == Ok("0")
  assert to_base(1, 2) == Ok("1")
  assert to_base(1, 8) == Ok("1")
  assert to_base(1, 10) == Ok("1")
  assert to_base(1, 16) == Ok("1")
  assert to_base(1, 36) == Ok("1")
  assert to_base(52_719, 2) == Ok("1100110111101111")
  assert to_base(52_719, 8) == Ok("146757")
  assert to_base(52_719, 10) == Ok("52719")
  assert to_base(52_719, 16) == Ok("cdef")
  assert to_base(52_719, 36) == Ok("14of")
  assert to_base(65_535, 2) == Ok("1111111111111111")
  assert to_base(65_535, 8) == Ok("177777")
  assert to_base(65_535, 10) == Ok("65535")
  assert to_base(65_535, 16) == Ok("ffff")
  assert to_base(65_535, 36) == Ok("1ekf")
  assert to_base(max_value, 0) == Err(Nil)
  assert to_base(max_value, -16) == Err(Nil)
  assert to_base(min_value, 37) == Err(Nil)
}

/// Returns `n` in decimal. It makes `U16` satisfy `Show`.
@external(native, "cheby_u16_show")
@external(js, "./u16.mjs", "show")
pub fn show(n: U16) -> String

// Comparison

/// Orders two `U16` values. It makes `U16` satisfy `Compare`.
pub fn compare(a: U16, b: U16) -> Order {
  case {
    a < b => Less
    a > b => Greater
    _ => Equal
  }
}

/// Returns the smaller of `a` and `b`, and `a` when they are `Equal`.
pub fn min(a: U16, b: U16) -> U16 {
  case {
    b < a => b
    _ => a
  }
}

/// Returns the larger of `a` and `b`, and `a` when they are `Equal`.
pub fn max(a: U16, b: U16) -> U16 {
  case {
    b > a => b
    _ => a
  }
}

// Arithmetic

/// Returns `a + b`, and panics when the result does not fit. It makes `U16` satisfy `Add`.
pub fn add(a: U16, b: U16) -> U16 {
  a + b
}

/// Returns `a - b`, and panics when the result does not fit. It makes `U16` satisfy `Sub`.
pub fn sub(a: U16, b: U16) -> U16 {
  a - b
}

/// Returns `a * b`, and panics when the result does not fit. It makes `U16` satisfy `Mul`.
pub fn mul(a: U16, b: U16) -> U16 {
  a * b
}

/// Returns `a / b` toward zero, panicking like `/`. It makes `U16` satisfy `Div`.
pub fn div(a: U16, b: U16) -> U16 {
  a / b
}

/// Returns `a % b`, with the sign of `a`, and panics on a zero divisor.
pub fn rem(a: U16, b: U16) -> U16 {
  a % b
}

/// Returns `-n`, and panics when it does not fit. It makes `U16` satisfy `Neg`.
pub fn neg(n: U16) -> U16 {
  -n
}

/// Returns `n`, since `U16` has no negative values.
pub fn abs(n: U16) -> U16 {
  n
}

// Checked arithmetic

/// Returns `Ok(a + b)`, or `Err(Nil)` when the sum does not fit (D-309).
@external(native, "cheby_u16_checked_add")
@external(js, "./u16.mjs", "checked_add")
pub fn checked_add(a: U16, b: U16) -> Result<U16, Nil>

/// Returns `Ok(a - b)`, or `Err(Nil)` when the difference does not fit (D-309).
@external(native, "cheby_u16_checked_sub")
@external(js, "./u16.mjs", "checked_sub")
pub fn checked_sub(a: U16, b: U16) -> Result<U16, Nil>

/// Returns `Ok(a * b)`, or `Err(Nil)` when the product does not fit (D-309).
@external(native, "cheby_u16_checked_mul")
@external(js, "./u16.mjs", "checked_mul")
pub fn checked_mul(a: U16, b: U16) -> Result<U16, Nil>

/// Returns `Ok(a / b)`, or `Err(Nil)` for a zero divisor (D-356).
pub fn checked_div(a: U16, b: U16) -> Result<U16, Nil> {
  case b {
    0 => Err(Nil)
    _ => Ok(a / b)
  }
}

/// Returns `Ok(a % b)`, or `Err(Nil)` for a zero divisor (D-356).
pub fn checked_rem(a: U16, b: U16) -> Result<U16, Nil> {
  case b {
    0 => Err(Nil)
    _ => Ok(a % b)
  }
}

/// Returns `Ok(n)` for 0, the only value whose negation fits, and `Err(Nil)` otherwise (D-309).
pub fn checked_neg(n: U16) -> Result<U16, Nil> {
  case n {
    0 => Ok(n)
    _ => Err(Nil)
  }
}

// Wrapping arithmetic

/// Returns `a + b` modulo 2^16 (D-025).
@external(native, "cheby_u16_wrapping_add")
@external(js, "./u16.mjs", "wrapping_add")
pub fn wrapping_add(a: U16, b: U16) -> U16

/// Returns `a - b` modulo 2^16 (D-025).
@external(native, "cheby_u16_wrapping_sub")
@external(js, "./u16.mjs", "wrapping_sub")
pub fn wrapping_sub(a: U16, b: U16) -> U16

/// Returns `a * b` modulo 2^16 (D-025).
@external(native, "cheby_u16_wrapping_mul")
@external(js, "./u16.mjs", "wrapping_mul")
pub fn wrapping_mul(a: U16, b: U16) -> U16

/// Returns `-n` modulo 2^16 (D-025).
@external(native, "cheby_u16_wrapping_neg")
@external(js, "./u16.mjs", "wrapping_neg")
pub fn wrapping_neg(n: U16) -> U16

// Tests of `std::int` that need this module.

test "from_u16 widens" {
  assert int::from_u16(max_value) == 65_535
}

// Examples

test "the u16 range" {
  assert min_value == 0
  assert max_value == 65_535
}

test "conversions to u16" {
  assert from_u8(255) == 255
  assert from_u32(65_535) == Ok(65_535)
  assert from_int(65_536) == Err(Nil)
  assert from_i16(-1) == Err(Nil)
  assert wrapping_from_u64(0x0123_4567_89AB_CDEF) == 0xCDEF
  assert wrapping_from_int(-1) == max_value
  assert wrapping_from_i16(-32_768) == 32_768
  assert wrapping_from_int(200) == 200
}

test "u16 parses and shows decimal digits" {
  let small: U16 = 7
  assert parse("65535") == Ok(65_535)
  assert parse("65536") == Err(Nil)
  assert parse_base("ffff", 16) == Ok(65_535)
  assert show(max_value) == "65535"
  assert "{small}" == "7"
  assert to_base(max_value, 16) == Ok("ffff")
  assert to_base(min_value, 2) == Ok("0")
  assert to_base(35, 36) == Ok("z")
  assert to_base(max_value, 37) == Err(Nil)
  assert to_base(max_value, 1) == Err(Nil)
}

test "comparing u16 values" {
  assert compare(1, 2) == Less
  assert compare(3, 3) == Equal
  assert min(100, 7) == 7
  assert max(100, 7) == 100
}

test "u16 operators as functions" {
  assert add(200, 55) == 255
  assert sub(7, 2) == 5
  assert mul(15, 17) == 255
  assert div(7, 2) == 3
  assert rem(7, 2) == 1
  assert neg(0) == 0
  assert abs(7) == 7
}

test "u16 checked arithmetic reports overflow" {
  assert checked_add(200, 55) == Ok(255)
  assert checked_add(max_value, 1) == Err(Nil)
  assert checked_sub(0, 1) == Err(Nil)
  assert checked_mul(max_value, 2) == Err(Nil)
  assert checked_div(7, 0) == Err(Nil)
  assert checked_rem(7, 2) == Ok(1)
  assert checked_neg(0) == Ok(0)
  assert checked_neg(1) == Err(Nil)
}

test "u16 wrapping arithmetic wraps around" {
  assert wrapping_add(max_value, 1) == 0
  assert wrapping_sub(0, 1) == max_value
  assert wrapping_mul(max_value, 2) == max_value - 1
  assert wrapping_neg(1) == max_value
}

// Puzzle helpers. They sit at the end of the file, so no std location that
// a golden pins moves (D-1603).

/// Returns the greatest common divisor of `a` and `b`, and `0` for
/// `gcd(0, 0)` (D-1606).
pub fn gcd(a: U16, b: U16) -> U16 {
  case b {
    0 => a
    _ => gcd(b, a % b)
  }
}

/// Returns the least common multiple of `a` and `b`, and `0` when either
/// is `0` (D-1606). It panics when the result does not fit.
pub fn lcm(a: U16, b: U16) -> U16 {
  case a, b {
    0, _ => 0
    _, 0 => 0
    _, _ => a / gcd(a, b) * b
  }
}

test "u16 gcd and lcm" {
  assert gcd(12, 18) == 6
  assert gcd(0, 5) == 5
  assert gcd(0, 0) == 0
  assert gcd(max_value, 5) == 5
  assert lcm(4, 6) == 12
  assert lcm(0, 6) == 0
  assert lcm(max_value, 1) == max_value
}
