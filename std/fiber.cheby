//! Fibers, scopes, joining, detached fibers, cancellation and timeouts
//! (§10.1 to §10.4, §10.7, §10.8, D-646).
//!
//! `Scope` and `Fiber<T>` are handles: external types whose drop
//! functions the runtime supplies (D-101, D-647, D-703). Every function
//! here is written in Cheby over private `@std_context` kernels (D-692)
//! and one compiler intrinsic, `scope_run` (D-693), none of which calls a
//! Cheby closure, so D-484 holds (D-675). `map` and `try_map` are written
//! over the other functions, with no kernel of their own (D-1098). Kernels
//! cannot build this module's records, so a `Panic` is built here from the
//! texts the runtime keeps for the scope that failed (D-484, D-648). Each
//! kernel and the intrinsic also declares its JS binding, written with the
//! JS back end (D-661).

import std::channel
import std::duration
import std::int
import std::list
import std::map as maps
import std::string

// Types

/// A scope that fibers are spawned into (§10.2, D-040). It prints as
/// `<Scope>`, and `==` and hashing panic when they reach one (D-233,
/// D-647).
pub type Scope

/// A fiber whose function returns a `T`, to be joined (§10.1, D-177). It
/// prints as `<Fiber>`, and `==` and hashing panic when they reach one
/// (D-233, D-647).
pub type Fiber<T>

/// The error of a failed scope: the message and the location of the first
/// panic in the scope (D-178, D-473). It is opaque and plain data. Two
/// panics are `==` when their messages and locations are equal, and its
/// debug text is `Panic { message: "…", location: "…" }` (D-648). It
/// satisfies `Show` through `show`.
pub type Panic {
  message: String,
  location: String,
}

/// The error of `timeout`: the limit passed first, or `f` panicked first
/// (D-181, D-199, D-649).
pub exposed type Timeout {
  TimedOut,
  Panicked(Panic),
}

// Scopes

/// Opens a scope, with a time limit of `seconds` and `nanoseconds` when
/// `timed`, calls `body` with it on the calling fiber, waits for every
/// fiber spawned into it and closes it. `Ok` holds `body`'s value; on
/// `Err(Nil)` the cause stays in the fiber for `take_failure` (D-693).
/// The compiler generates the body of this intrinsic, so no Cheby call
/// comes between opening and closing the scope (D-665, D-666).
@external(native, "cheby_rt_scope_run")
@external(js, "./fiber.mjs", "scope_run")
fn scope_run<T>(timed: Bool, seconds: Int, nanoseconds: Int, body: fn(Scope) -> T) -> Result<T, Nil>

/// Why the scope that `scope_run` just closed failed: 0 for a panic and 1
/// for an expired limit, then the panic's message and location (D-473,
/// D-648, D-755).
@std_context
@external(native, "cheby_fiber_take_failure")
@external(js, "./fiber.mjs", "take_failure")
fn take_failure() -> (Int, String, String)

/// Opens a new scope, calls `body` with it on the calling fiber, and
/// returns `Ok` with `body`'s value once `body` has returned and every
/// fiber spawned into the scope has ended (§10.2, D-040, D-665, D-666).
/// The first member to panic makes the scope fail: the others are
/// cancelled, and `scope` returns `Err` with that panic, which is not
/// printed (D-176, D-178, D-701). When the scope fails, the value of
/// `body` is released.
pub fn scope<T>(body: fn(Scope) -> T) -> Result<T, Panic> {
  case scope_run(False, 0, 0, body) {
    Ok(value) => Ok(value)
    Err(Nil) => {
      // `message` is a function of this module, so no binding may take
      // the name, and the pair is bound as `text` and `place` (D-051).
      let (_, text, place) = take_failure()
      Err(Panic { message: text, location: place })
    }
  }
}

test "a scope returns its body's value once its fibers have ended" {
  let (tx, rx) = channel::new::<Int>(0)
  let outcome = {
    use owner <- scope()
    spawn(owner, fn() { channel::send(tx, 1) })
    channel::receive(rx)
  }
  assert outcome == Ok(Ok(1))
}

test "a scope waits for every fiber spawned into it" {
  let (tx, rx) = channel::new::<Int>(3)
  let outcome = {
    use owner <- scope()
    spawn(owner, fn() { spawn(owner, fn() { channel::send(tx, 2) }) })
    Nil
  }
  assert outcome == Ok(Nil)
  assert channel::receive(rx) == Ok(2)
  assert channel::receive(rx) == Err(Nil)
}

test "a panic in the body is caught by its scope" {
  let outcome = {
    use _scope <- scope()
    panic as "boom"
  }
  let assert Err(failure) = outcome
  assert message(failure) == "boom"
}

test "a panic in a fiber cancels the body" {
  let (keep, never) = channel::new::<Int>(1)
  let outcome = {
    use owner <- scope()
    spawn(owner, fn() { panic as "first" })
    // Nothing is ever sent on `never`, so only the cancellation ends
    // this wait.
    channel::receive(never)
  }
  let assert Err(failure) = outcome
  assert message(failure) == "first"
  // Unwinding the body released `never`, the only `Receiver`.
  assert channel::send(keep, 1) == Err(1)
}

test "a nested scope keeps a fiber's panic to itself" {
  let outcome = {
    use outer <- scope()
    let inner = spawn(outer, fn() {
      use owner <- scope()
      spawn(owner, fn() { panic as "inner" })
    })
    case join(inner) {
      Ok(_) => "no panic"
      Err(failure) => message(failure)
    }
  }
  assert outcome == Ok("inner")
}

test "fibers and scopes print as placeholders" {
  let outcome = {
    use owner <- scope()
    let child = spawn(owner, fn() { Nil })
    "{owner:?} {child:?}"
  }
  assert outcome == Ok("<Scope> <Fiber>")
}

// Spawning

/// Starts a fiber in `owner` that calls `f`, with the default stack, and
/// returns it at once. Panics with `spawn into a scope that has ended`
/// when `owner` has ended (D-666, D-732, D-755).
@std_context
@external(native, "cheby_fiber_sys_spawn")
@external(js, "./fiber.mjs", "sys_spawn")
fn sys_spawn<T>(owner: Scope, f: fn() -> T) -> Fiber<T>

/// Starts a new fiber in the scope `owner` that calls `f`, and returns the
/// fiber at once. The new fiber runs concurrently with the caller,
/// possibly in parallel, and has the default stack (§10.1, D-125). `f` is
/// called exactly once, on the new fiber, and released no later than when
/// the call returns or unwinds (D-205, D-670). If `owner` has failed or
/// has been cancelled, `f` is never called (D-666). It panics with `spawn
/// into a scope that has ended` when `owner` has ended (§10.3, D-666,
/// D-732).
pub fn spawn<T>(owner: Scope, f: fn() -> T) -> Fiber<T> {
  sys_spawn(owner, f)
}

test "spawning into a scope that has ended panics" {
  let assert Ok(ended) = {
    use owner <- scope()
    owner
  }
  let outcome = {
    use _scope <- scope()
    spawn(ended, fn() { Nil })
  }
  let assert Err(failure) = outcome
  assert message(failure) == "spawn into a scope that has ended"
}

/// Starts a fiber in `owner` that calls `f`, with a stack of `stack_bytes`
/// bytes clamped to 1 MiB to 16 GiB and rounded up to the page size
/// (D-659, D-660, D-677).
@std_context
@external(native, "cheby_fiber_sys_spawn_with_stack")
@external(js, "./fiber.mjs", "sys_spawn_with_stack")
fn sys_spawn_with_stack<T>(owner: Scope, stack_bytes: Int, f: fn() -> T) -> Fiber<T>

/// Like `spawn`, but the new fiber's stack reserves `stack_bytes` bytes of
/// address space instead of the default; only touched pages use memory
/// (D-124, D-125, D-659). `stack_bytes` is clamped to 1 MiB to 16 GiB and
/// rounded up to the page size (D-298, D-660). On JS it has no effect
/// (D-094, D-232).
@std_clamped(stack_bytes)
pub fn spawn_with_stack<T>(owner: Scope, stack_bytes: Int, f: fn() -> T) -> Fiber<T> {
  sys_spawn_with_stack(owner, stack_bytes, f)
}

@target(native)
test "a fiber can have a larger stack" {
  fn depth(n) {
    case n {
      0 => 0
      _ => 1 + depth(n - 1)
    }
  }
  let outcome = {
    use owner <- scope()
    let deep = spawn_with_stack(owner, 64 * 1024 * 1024, fn() { depth(100_000) })
    join(deep)
  }
  assert outcome == Ok(100_000)
}

/// Starts a detached fiber that calls `f` (D-669).
@std_context
@external(native, "cheby_fiber_sys_spawn_detached")
@external(js, "./fiber.mjs", "sys_spawn_detached")
fn sys_spawn_detached<T>(f: fn() -> T)

/// Starts a new detached fiber that calls `f`, outside every scope, and
/// returns at once (§10.4, D-040, D-669). Nobody waits for it and no
/// cancellation reaches it. Its panic is printed as a panic report (§11.6,
/// D-449, D-701). The program kills detached fibers still running when
/// `main` and its scopes have finished (§10.10, D-073), and a test's
/// detached fibers end with the test (D-723).
pub fn spawn_detached<T>(f: fn() -> T) {
  sys_spawn_detached(f)
}

test "a detached fiber runs on its own" {
  let (tx, rx) = channel::new::<Int>(0)
  spawn_detached(fn() { channel::send(tx, 5) })
  assert channel::receive(rx) == Ok(5)
}

// Joining

/// Waits until `fiber` has ended and returns its value. Panics with
/// `joined fiber failed` when the fiber failed and the caller is not
/// being cancelled with its scope (D-668, D-732, D-755).
@std_context
@external(native, "cheby_fiber_sys_join")
@external(js, "./fiber.mjs", "sys_join")
fn sys_join<T>(fiber: Fiber<T>) -> T

/// Waits until `fiber` has ended and returns its value directly (D-177).
/// Any fiber may join, any number of times, and each call returns the same
/// value. If `fiber` panicked or was cancelled, `join` never returns: a
/// joiner inside the fiber's scope is cancelled with it, and any other
/// joiner panics with `joined fiber failed` (D-668).
pub fn join<T>(fiber: Fiber<T>) -> T {
  sys_join(fiber)
}

test "join returns the fiber's value every time" {
  let outcome = {
    use owner <- scope()
    let answer = spawn(owner, fn() { 6 * 7 })
    join(answer) + join(answer)
  }
  assert outcome == Ok(84)
}

test "joining a failed fiber from outside its scope panics" {
  let (tx, rx) = channel::new::<Fiber<Never>>(1)
  let (go_tx, go_rx) = channel::new::<Nil>(1)
  let first = {
    use owner <- scope()
    let doomed = spawn(owner, fn() {
      let _ = channel::receive(go_rx)
      panic as "doomed"
    })
    let assert Ok(Nil) = channel::send(tx, doomed)
    let assert Ok(Nil) = channel::send(go_tx, Nil)
    Nil
  }
  let assert Err(_) = first
  let assert Ok(doomed) = channel::receive(rx)
  let second = {
    use _scope <- scope()
    join(doomed)
  }
  let assert Err(failure) = second
  assert message(failure) == "joined fiber failed"
}

// Cancellation

/// Cancels every fiber spawned into `owner` so far, and every scope nested
/// in them, with `owner` as the target, but never `owner`'s body; does not
/// return when the caller is one of them, and does nothing on a scope that
/// has ended, failed or been cancelled (D-102, D-667, D-1060).
@std_context
@external(native, "cheby_fiber_sys_cancel")
@external(js, "./fiber.mjs", "sys_cancel")
fn sys_cancel(owner: Scope) -> Nil

/// Cancels every fiber spawned into `owner` so far, and every scope nested
/// in them, with `owner` as the target (D-667, D-1060, ADR-0069). It never
/// cancels `owner`'s body and does not mark the scope as cancelled:
/// fibers spawned into it afterwards run normally, and the scope returns
/// `Ok` with the body's value once every fiber has ended. A panic of a
/// fiber after `cancel` has reached it is not recorded (D-671). Any fiber
/// that holds the `Scope` may call it; when the caller is one of the
/// fibers it cancels, `cancel` does not return and the caller unwinds at
/// once (D-102). On a scope that has ended, failed or been cancelled it
/// does nothing. A joiner of a cancelled fiber follows `join`'s rule
/// (D-668).
pub fn cancel(owner: Scope) {
  sys_cancel(owner)
}

test "cancel stops the fibers of a scope but not its body" {
  let (keep, never) = channel::new::<Int>(1)
  let outcome = {
    use owner <- scope()
    spawn(owner, fn() { channel::receive(never) })
    cancel(owner)
    "body"
  }
  assert outcome == Ok("body")
  // The cancelled fiber released `never`, the only `Receiver`.
  assert channel::send(keep, 1) == Err(1)
}

test "fibers spawned after cancel run normally" {
  let outcome = {
    use owner <- scope()
    cancel(owner)
    let later = spawn(owner, fn() { 6 * 7 })
    join(later)
  }
  assert outcome == Ok(42)
}

test "a fiber that cancels its own scope unwinds at once" {
  let (tx, rx) = channel::new::<Int>(1)
  let outcome = {
    use owner <- scope()
    spawn(owner, fn() {
      cancel(owner)
      channel::send(tx, 1)
    })
    Nil
  }
  assert outcome == Ok(Nil)
  // The fiber never reached its send, and unwinding released `tx`.
  assert channel::receive(rx) == Err(Nil)
}

test "joining a fiber that cancel reached fails the scope" {
  let (keep, never) = channel::new::<Int>(1)
  let outcome = {
    use owner <- scope()
    let waiting = spawn(owner, fn() { channel::receive(never) })
    cancel(owner)
    join(waiting)
  }
  let assert Err(failure) = outcome
  assert message(failure) == "joined fiber failed"
  assert channel::send(keep, 1) == Err(1)
}

/// Calls each function of `contenders` on a fiber of its own, in a scope
/// of its own, and returns `Ok(Some(value))` with the value of the first
/// one to return, once the others, which it cancels, have unwound
/// (D-1061). An empty list gives `Ok(None)` and spawns nothing. A
/// contender that panics before the race is decided makes it `Err` with
/// that panic; a panic after that is not recorded (D-1060). It is written
/// over `scope`, `spawn`, a channel and `cancel`, with no kernel.
pub fn race<T>(contenders: List<fn() -> T>) -> Result<Option<T>, Panic> {
  let outcome = {
    use owner <- scope()
    let (tx, rx) = channel::new::<Result<T, Panic>>(0)
    fn start(rest) {
      case rest {
        [] => Nil
        [contender, ..others] => {
          // Each contender runs in a nested scope and sends how it ended,
          // so the first message decides the race: a panic that comes
          // later stays in its own scope and is never recorded (D-1061).
          spawn(owner, fn() { channel::send(tx, scope(fn(_) { contender() })) })
          start(others)
        }
      }
    }
    start(contenders)
    // `start` is not used again, so it is released here together with the
    // `tx` it captured (D-205). Only the contenders hold a `Sender` now, so
    // `rx` closes at once when there are none.
    let first = channel::receive(rx)
    // `rx` is released after its last use, so contenders blocked in `send`
    // get their value back and end. `cancel` stops the ones still working.
    cancel(owner)
    first
  }
  case outcome {
    Ok(Ok(Ok(value))) => Ok(Some(value))
    Ok(Ok(Err(failure))) => Err(failure)
    Ok(Err(Nil)) => Ok(None)
    Err(failure) => Err(failure)
  }
}

test "race returns the first value and cancels the rest" {
  let (keep, never) = channel::new::<Int>(1)
  let slow = fn() {
    let _ = channel::receive(never)
    2
  }
  let outcome = race([fn() { 1 }, slow])
  assert outcome == Ok(Some(1))
  // The slow contender was cancelled and released `never`.
  assert channel::send(keep, 1) == Err(1)
}

test "race of no contenders is None" {
  assert race::<Int>([]) == Ok(None)
}

test "a panic before the race is decided fails it" {
  let (keep, never) = channel::new::<Int>(1)
  let slow = fn() {
    let _ = channel::receive(never)
    2
  }
  let outcome = race([slow, fn() { panic as "lost" }])
  let assert Err(failure) = outcome
  assert message(failure) == "lost"
  assert channel::send(keep, 1) == Err(1)
}

/// Calls `f` on the calling fiber, in a new scope, and cancels it if it
/// has not finished within `limit` (§10.8, D-103, D-181, D-665, D-671).
/// `Ok` holds `f`'s value when it returned first, `Err(Panicked(p))` holds
/// its panic when it panicked first, and `Err(TimedOut)` comes once
/// `limit` has passed and everything in the scope has ended. A `limit` of
/// zero or less has already passed, so `f` is not called (D-652).
/// `timeout` releases `f` before it returns (D-670).
pub fn timeout<T>(limit: duration::Duration, f: fn() -> T) -> Result<T, Timeout> {
  case duration::compare(limit, duration::zero) {
    Greater => {
      let seconds = duration::to_seconds(limit)
      let nanoseconds = duration::to_nanoseconds(limit - duration::seconds(seconds))
      case scope_run(True, seconds, nanoseconds, fn(_owner) { f() }) {
        Ok(value) => Ok(value)
        Err(Nil) => case take_failure() {
          (0, text, place) => Err(Panicked(Panic { message: text, location: place }))
          _ => Err(TimedOut)
        }
      }
    }
    _ => Err(TimedOut)
  }
}

test "timeout returns the value of work that finishes in time" {
  assert timeout(duration::seconds(10), fn() { 6 * 7 }) == Ok(42)
}

test "timeout cancels work that takes too long" {
  let (keep, never) = channel::new::<Int>(1)
  let outcome = timeout(duration::milliseconds(10), fn() { channel::receive(never) })
  assert outcome == Err(TimedOut)
  // `f` was released before `timeout` returned, and with it `never`.
  assert channel::send(keep, 1) == Err(1)
}

test "timeout reports a panic as Panicked" {
  let outcome = timeout(duration::seconds(10), fn() { panic as "crash" })
  let assert Err(Panicked(failure)) = outcome
  assert message(failure) == "crash"
}

test "a limit of zero times out without calling f" {
  let outcome = timeout(duration::seconds(0), fn() { panic as "not called" })
  assert outcome == Err(TimedOut)
}

test "a timeout cancels the scopes inside it without their returning" {
  let (keep, never) = channel::new::<Int>(1)
  let outcome = timeout(duration::milliseconds(10), fn() {
    let inner = {
      use owner <- scope()
      spawn(owner, fn() { channel::receive(never) })
    }
    // Not reached: a scope that is cancelled from outside never
    // returns.
    case inner {
      Ok(_) => "returned"
      Err(_) => "failed"
    }
  })
  assert outcome == Err(TimedOut)
  assert channel::send(keep, 1) == Err(1)
}

// Interrupts

/// Makes the first SIGINT or SIGTERM that the process receives while
/// `owner` is open cancel it, with `owner` as the target, as an expired
/// limit cancels a timed scope (D-790, D-1073). `owner` is the scope that
/// `interruptible` just opened, and its close stops the signal from
/// reaching it on every path out. Under `cheby test`, in the REPL and on
/// Windows it does nothing.
@std_context
@external(native, "cheby_fiber_sys_arm_interrupt")
@external(js, "./fiber.mjs", "sys_arm_interrupt")
priv fn sys_arm_interrupt(owner: Scope) -> Nil

/// Calls `f` on the calling fiber in a new scope that the first SIGINT or
/// SIGTERM cancels, for `process::until_interrupted` (D-675, D-1073). `Ok`
/// holds `f`'s value when it returned first, `Err(Some(p))` holds its panic
/// when it panicked first, and `Err(None)` comes once a signal cancelled
/// the scope and everything in it has ended. It is package-visible:
/// `std::process` cannot build a `Panic`.
fn interruptible<T>(f: fn() -> T) -> Result<T, Option<Panic>> {
  let body = fn(owner) {
    sys_arm_interrupt(owner)
    f()
  }
  case scope_run(False, 0, 0, body) {
    Ok(value) => Ok(value)
    Err(Nil) => case take_failure() {
      (0, text, place) => Err(Some(Panic { message: text, location: place }))
      _ => Err(None)
    }
  }
}

test "interruptible returns the value of a body that finishes" {
  assert interruptible(fn() { 6 * 7 }) == Ok(42)
}

test "interruptible reports a panic as the panic" {
  let assert Err(Some(failure)) = interruptible(fn() { panic as "crash" })
  assert message(failure) == "crash"
}

// Parallel work

/// The work of `map` and `try_map` (D-1098). It starts the calls of `f`
/// in the order of `xs`, each on a fiber of its own in a scope of its own,
/// at most `limit` at a time, and starts the next one each time a call
/// ends, until a call returns `Err`. Each call sends its index and its
/// result back on a channel with room for all of them, so a call never
/// waits to send. The results are put in order as they come: those that
/// come before their turn wait in a map until it comes. The answer is known
/// once every call before the lowest `Err` so far has returned `Ok`, or
/// every call has returned `Ok`. Then the calls still running, all of them
/// after that `Err`, are cancelled, and the scope ends once they have
/// unwound. A panic of a call fails the scope, which cancels the others and
/// the body, and its `Panic` is raised again (D-1097).
fn run_parallel<T, U, E>(xs: List<T>, limit: Int, f: fn(T) -> Result<U, E>) -> Result<List<U>, E> {
  let total = list::length(xs)
  let width = int::min(int::max(limit, 1), total)
  case total {
    0 => Ok([])
    _ => {
      let outcome = {
        use owner <- scope()
        let (tx, rx) = channel::new::<(Int, Result<U, E>)>(width)
        // Calls `f` on `x`, the element at `index`, on a fiber of its own.
        fn launch(index, x) {
          spawn(owner, fn() { channel::send(tx, (index, f(x))) })
        }
        // Starts the first `width` calls and returns the elements left.
        fn start(index, rest) {
          case rest {
            [x, ..others] when index < width => {
              launch(index, x)
              start(index + 1, others)
            }
            _ => rest
          }
        }
        // Moves the results that wait in `early` from index `at` on into
        // `ready`, which holds the results before `at` in reverse order.
        fn drain(at, ready, early) {
          case maps::get(early, at) {
            Some(value) => drain(at + 1, [value, ..ready], maps::remove(early, at))
            None => (at, ready, early)
          }
        }
        // `started` calls have started and `rest` holds the elements not
        // started; `next` is the index of the first result not in `ready`,
        // `early` holds the results after it, and `failed` the `Err` of the
        // lowest index so far, with that index.
        fn gather(started, rest, next, ready, early, failed) {
          case failed {
            Some((at, error)) when at == next => {
              cancel(owner)
              Err(error)
            }
            _ => case next == total {
              True => Ok(list::reverse(ready))
              False => {
                // The body holds `tx` through `launch`, so the channel
                // stays open.
                let assert Ok((index, returned)) = channel::receive(rx)
                let lowest = case returned, failed {
                  Err(error), None => Some((index, error))
                  Err(error), Some((at, _)) when index < at => Some((index, error))
                  _, _ => failed
                }
                let (moved, in_order, waiting) = case returned {
                  Ok(value) when index == next => drain(next + 1, [value, ..ready], early)
                  Ok(value) => (next, ready, maps::insert(early, index, value))
                  Err(_) => (next, ready, early)
                }
                // No call starts once one has returned `Err`: the calls
                // before it have all started.
                let (launched, left) = case lowest, rest {
                  None, [x, ..others] => {
                    launch(started, x)
                    (started + 1, others)
                  }
                  _, _ => (started, rest)
                }
                gather(launched, left, moved, in_order, waiting, lowest)
              }
            }
          }
        }
        let remaining = start(0, xs)
        gather(width, remaining, 0, [], maps::new(), None)
      }
      case outcome {
        Ok(answer) => answer
        Err(failure) => raise(failure)
      }
    }
  }
}

/// Calls `f` once per element of `xs`, on at most `limit` fibers at a
/// time, in a scope of its own, and returns the results in the order of
/// `xs`, as `list::map(xs, f)` does (D-1098). The calls start in the order
/// of `xs`, and `limit` is clamped to at least 1 (D-298). When a call
/// panics, the other calls are cancelled, and once they have unwound, the
/// panic that the scope records is raised again with `raise`, so it keeps
/// its message and location; which one that is can depend on timing when
/// several calls panic (D-232). An empty list gives `[]` and spawns
/// nothing. The elements, `f`'s captures and the results cross fibers, so
/// they become shared (§9.4).
@std_clamped(limit)
pub fn map<T, U>(xs: List<T>, limit: Int, f: fn(T) -> U) -> List<U> {
  case run_parallel::<T, U, Never>(xs, limit, fn(x) { Ok(f(x)) }) {
    Ok(ys) => ys
    Err(nothing) => nothing
  }
}

test "map keeps the order of its input" {
  let inputs = list::range(1, 101)
  assert map(inputs, 8, fn(n) { n * n }) == list::map(inputs, fn(n) { n * n })
}

test "map clamps its limit to at least 1" {
  assert map([3, 1, 2], 0, fn(n) { n * 2 }) == [6, 2, 4]
  assert map::<Int, Int>([], 4, fn(n) { n * 2 }) == []
}

test "map raises the panic of a call again" {
  let outcome = {
    use _scope <- scope()
    map([1, 2, 3], 2, fn(n) {
      case n {
        2 => panic as "two"
        _ => n
      }
    })
  }
  let assert Err(failure) = outcome
  assert message(failure) == "two"
}

/// Calls `f` on the elements of `xs`, on at most `limit` fibers at a time,
/// in a scope of its own, and returns `Ok` with every result in the order
/// of `xs`, or the `Err` of the element with the lowest index whose call
/// returned `Err`, as `list::try_map(xs, f)` does when `f` has no effects,
/// whatever the scheduling (D-1098). `f` is called exactly once for each
/// element before that one and at most once for each element after it:
/// once the answer is known, no more elements are handed out, and the calls
/// in flight are cancelled and have unwound before it returns. A panic of
/// a call before the answer is known is raised again, as in `map`.
/// `limit` is clamped to at least 1 (D-298), and an empty list gives
/// `Ok([])` and spawns nothing.
@std_clamped(limit)
pub fn try_map<T, U, E>(xs: List<T>, limit: Int, f: fn(T) -> Result<U, E>) -> Result<List<U>, E> {
  run_parallel(xs, limit, f)
}

test "try_map returns the Err of the lowest index" {
  let check = fn(n) {
    case n > 2 {
      True => Err(n)
      False => Ok(n)
    }
  }
  assert try_map([1, 2, 3, 4, 5], 4, check) == Err(3)
  assert try_map([1, 2], 4, check) == Ok([1, 2])
  assert try_map([], 4, check) == Ok([])
}

test "try_map calls each element before the Err exactly once" {
  let (tx, rx) = channel::new::<Int>(4)
  let outcome = try_map([1, 2, 3, 4], 1, fn(n) {
    let assert Ok(Nil) = channel::send(tx, n)
    case n {
      2 => Err("two")
      _ => Ok(n)
    }
  })
  assert outcome == Err("two")
  // The function, and with it `tx`, is released once `try_map` returns.
  let calls = list::sort(channel::to_list(rx))
  assert list::take(calls, 2) == [1, 2]
  assert list::unique(calls) == calls
}

test "try_map cancels the calls in flight" {
  let (keep, never) = channel::new::<Int>(1)
  let outcome = try_map([1, 2], 2, fn(n) {
    case n {
      1 => Err("one")
      _ => {
        let _ = channel::receive(never)
        Ok(n)
      }
    }
  })
  assert outcome == Err("one")
  // The call for 2 was cancelled, and `never` was released.
  assert channel::send(keep, 1) == Err(1)
}

// Yielding

/// Puts the calling fiber behind the fibers that can run, once, and
/// delivers a pending cancellation (D-1102).
@std_context
@external(native, "cheby_fiber_sys_yield_now")
@external(js, "./fiber.mjs", "sys_yield_now")
fn sys_yield_now() -> Nil

/// Suspends the calling fiber once and puts it behind the fibers that can
/// run, then returns (D-1102). A pending cancellation is delivered there,
/// as at any suspension point (§10.7). On JS it is a real suspension point,
/// the one portable way for a CPU-bound loop to let the other fibers run
/// (§10.2, D-185). On native the entry checks already keep a fiber from
/// holding a thread (D-028), so it only makes the switch happen at once.
pub fn yield_now() {
  sys_yield_now()
}

test "a loop that yields lets other fibers run" {
  let (tx, rx) = channel::new::<Int>(1)
  let outcome = {
    use owner <- scope()
    spawn(owner, fn() { channel::send(tx, 1) })
    fn poll() {
      case channel::receive_now(rx) {
        Some(received) => received
        None => {
          yield_now()
          poll()
        }
      }
    }
    poll()
  }
  assert outcome == Ok(Ok(1))
}

test "a cancellation is delivered at yield_now" {
  fn spin(n: Int) -> Int {
    yield_now()
    spin(n + 1)
  }
  let outcome = timeout(duration::milliseconds(10), fn() { spin(0) })
  assert outcome == Err(TimedOut)
}

// Panics

/// Returns the message of the panic: exactly the message line of its
/// panic report, without the `panicked at` line, the location or any
/// prefix (§11.6, D-449, D-473).
pub fn message(failure: Panic) -> String {
  failure.message
}

test "message is the panic's message line" {
  let outcome = {
    use _scope <- scope()
    todo as "later"
  }
  let assert Err(failure) = outcome
  assert message(failure) == "not implemented: later"
}

/// Makes `Panic` satisfy `Show` (§8.8). The text is the panic report of
/// §11.6 without its final line ending: `panicked at <location>:`, a line
/// ending, and the message, so `main` returning `Err(p)` prints what the
/// panic would have printed (§10.10, D-182, D-449, D-648).
pub fn show(failure: Panic) -> String {
  "panicked at {failure.location}:\n{failure.message}"
}

test "a panic shows like a panic report" {
  let assert Err(failure) = {
    use _scope <- scope()
    panic as "boom"
  }
  let text = show(failure)
  assert string::starts_with(text, "panicked at ")
  assert string::ends_with(text, ":\nboom")
  assert string::starts_with("{failure:?}", "Panic \{ message: \"boom\", location: \"")
}

test "panics compare by message and location" {
  fn fail(text) {
    let assert Err(failure) = {
      use _scope <- scope()
      panic as text
    }
    failure
  }
  assert fail("same") == fail("same")
  assert fail("same") != fail("other")
}

/// Panics on the calling fiber with `text` as the message and `place` as
/// the location, as they are (D-1097). `message` is a function of this
/// module, so no parameter may take the name (D-051).
@std_context
@external(native, "cheby_fiber_sys_raise")
@external(js, "./fiber.mjs", "sys_raise")
fn sys_raise(text: String, place: String) -> Never

/// Panics on the calling fiber with `failure`'s message and location
/// (D-1097). A scope that catches it gets a `Panic` that is `==` to
/// `failure`, and an uncaught one prints the original `panicked at
/// <location>:` line and message (§11.6). The backtrace, when it is on,
/// starts with the line `  in std::fiber::raise`, with no location, and goes on
/// with the calling fiber's stack at the call of `raise`, since the
/// original stack has unwound (D-1039).
pub fn raise(failure: Panic) -> Never {
  sys_raise(failure.message, failure.location)
}

test "raise keeps the message and location of a caught panic" {
  let assert Err(first) = {
    use _scope <- scope()
    panic as "original"
  }
  let assert Err(again) = {
    use _scope <- scope()
    raise(first)
  }
  assert again == first
  assert message(again) == "original"
}

test "a raised panic fails a scope like the original" {
  let assert Err(first) = {
    use _scope <- scope()
    panic as "worker"
  }
  let outcome = {
    use owner <- scope()
    spawn(owner, fn() { raise(first) })
    Nil
  }
  assert outcome == Err(first)
}

// Tests of `std::channel` that need this module.

test "a negative capacity counts as 0" {
  let capacity = -1
  let (tx, rx) = channel::new::<Int>(capacity)
  // Nobody receives, so a send on a capacity-0 channel waits.
  let attempt = timeout(duration::milliseconds(10), fn() { channel::send(tx, 1) })
  assert attempt == Err(TimedOut)
  // The cancelled send delivered nothing, and the only `Sender` is gone.
  assert channel::receive(rx) == Err(Nil)
}

test "a capacity-0 send completes when a receiver takes the value" {
  let (tx, rx) = channel::new::<String>(0)
  let outcome = {
    use owner <- scope()
    let sender = spawn(owner, fn() { channel::send(tx, "hello") })
    let received = channel::receive(rx)
    (received, join(sender))
  }
  assert outcome == Ok((Ok("hello"), Ok(Nil)))
}

test "send_all and to_list pass a list between fibers" {
  let (tx, rx) = channel::new::<Int>(0)
  let outcome = {
    use owner <- scope()
    spawn(owner, fn() { channel::send_all(tx, [1, 2, 3, 4]) })
    channel::to_list(rx)
  }
  assert outcome == Ok([1, 2, 3, 4])
}

test "send_all stops when the last Receiver goes" {
  let (tx, rx) = channel::new::<Int>(0)
  let outcome = {
    use owner <- scope()
    let sender = spawn(owner, fn() { channel::send_all(tx, [1, 2, 3]) })
    let first = channel::receive(rx)
    // `rx` is not used again, so the sender's next send fails.
    (first, join(sender))
  }
  assert outcome == Ok((Ok(1), Err([2, 3])))
}

// Tests of `std::duration` that need this module.

test "scale panics where the result does not fit" {
  let outcome = {
    use _scope <- scope()
    duration::scale(duration::hours(1), 2_562_047_788_015_216)
  }
  let assert Err(failure) = outcome
  assert message(failure) == "integer overflow"
}

@target(native)
test "scale panics just past the largest span" {
  // 1.5 s times this is 2⁶³ + 1 s, past the largest span.
  let factor = int::max_value / 3 * 2 + 2
  let fits = duration::scale(duration::milliseconds(1_500), factor - 1)
  assert fits == duration::seconds(int::max_value) + duration::milliseconds(500)
  let outcome = {
    use _scope <- scope()
    duration::scale(duration::milliseconds(1_500), factor)
  }
  let assert Err(failure) = outcome
  assert message(failure) == "integer overflow"
}
