//! JSON text as RFC 8259 defines it: parsing it, writing values as text,
//! and the type `Value` that holds any JSON document (D-210, ADR-0038).
//! Typed data is read with the decoders of `std::json::decode` (D-320) and
//! written with encoding functions that return a `Value`.
//!
//! The module is written in Cheby over the kernels of `std::bytes`,
//! `std::string`, `std::int` and `std::float` (D-274). The parser lives in
//! `std::json::tree`, because `std::json::decode` cannot import this module
//! (D-361, ADR-0053). It scans the bytes of the text and builds a `Value`
//! for `parse_value`, or the raw tree that decoders run over for `parse`.
//! The writer adds each piece of text to the end of one string, each string
//! quoted and escaped by the package-visible `string::add_json_quoted`
//! (D-903), and keeps the rest of each open array and object on a stack on
//! the heap. Neither parsing nor writing grows the stack with the nesting
//! depth of a document (D-094, D-326).

// The module has a function named `list`, so it imports `std::list` under
// another name (§7.5.1, D-062).
import std::float
import std::int
import std::json::decode
import std::json::tree
import std::list as lists
import std::result
import std::string

/// Any JSON document (D-321, ADR-0052). An `Object` keeps its members in the
/// order written, repeated keys included (D-218, D-223).
pub exposed type Value {
  Null,
  Bool(Bool),
  Int(Int),
  Float(Float),
  String(String),
  Array(List<Value>),
  Object(List<(String, Value)>),
}

/// A place in JSON text: the line and the column in code points, both
/// counting from 1 (D-324).
pub exposed type Position {
  line: Int,
  column: Int,
}

/// Why `parse` failed: the text is not JSON, or the decoder did not accept
/// it (D-304, ADR-0051).
pub exposed type Error {
  Syntax(Position),
  Decode(List<decode::Error>),
}

/// A type that can be written as a JSON value (D-320).
pub interface ToJson {
  fn to_json(Self) -> Value
}

// Encoding

/// Returns an `Array` holding `encode` applied to each element of `items` (D-321).
pub fn array<T>(items: List<T>, encode: fn(T) -> Value) -> Value {
  Array(lists::map(items, encode))
}

test "array encodes each element with the given function" {
  assert array(["a", "b"], String) == Array([String("a"), String("b")])
  assert to_string(array([1, 2], Int)) == "[1,2]"
}

/// Returns `encode` applied to the value of a `Some`, and `Null` for `None` (D-321).
pub fn nullable<T>(option: Option<T>, encode: fn(T) -> Value) -> Value {
  case option {
    Some(item) => encode(item)
    None => Null
  }
}

test "nullable writes null for None" {
  assert nullable(Some(1920), Int) == Int(1920)
  assert nullable(None, Int) == Null
}

/// Returns an `Array` holding the `to_json` of each element of `items` (D-320).
pub fn list<T: ToJson>(items: List<T>) -> Value {
  Array(lists::map(items, fn(item) { ToJson::to_json(item) }))
}

// A type for the test of `list`. Its `to_json` makes it satisfy `ToJson`.
// User builds skip std tests, and satisfaction is not a written use, so the
// test also names `to_json`, or it would be reported unused (D-479, D-516).
priv type Point {
  x: Int,
  y: Int,
}

priv fn to_json(point: Point) -> Value {
  Object([("x", Int(point.x)), ("y", Int(point.y))])
}

test "list encodes each element with its type's to_json" {
  let points = [Point { x: 1, y: 2 }, Point { x: 3, y: 4 }]
  assert to_string(list(points)) == r#"[{"x":1,"y":2},{"x":3,"y":4}]"#
  assert list(points) == array(points, to_json)
}

/// Returns `document` as compact JSON text, with no whitespace between tokens
/// (D-325, D-326, D-398).
pub fn to_string(document: Value) -> String {
  write(document, False)
}

test "to_string writes compact JSON" {
  let document = Object([
    ("title", String("Dune")),
    ("year", Int(1965)),
    ("rating", Float(4.0)),
    ("tags", Array([String("classic"), Null])),
    ("read", Bool(False)),
  ])
  let text = to_string(document)
  assert text == r#"{"title":"Dune","year":1965,"rating":4.0,"tags":["classic",null],"read":false}"#
  assert parse_value(text) == Ok(document)
}

test "to_string writes floats as show does, and non-finite ones as null" {
  assert to_string(Float(1.0e21)) == "1.0e21"
  assert to_string(Float(-0.0)) == "-0.0"
  assert to_string(Float(float::nan)) == "null"
  assert to_string(Float(float::infinity)) == "null"
}

test "to_string escapes only quotes, backslashes and control characters" {
  assert to_string(String("say \"hi\"\n")) == r#""say \"hi\"\n""#
  assert to_string(String("a\\b/c")) == r#""a\\b/c""#
  assert to_string(String("\u{1}é\u{1F600}")) == "\"\\u0001é\u{1F600}\""
}

/// Returns `document` as JSON text indented by two spaces, with `": "` after
/// each key and no final line ending, as `JSON.stringify(document, null, 2)`
/// writes it (D-327).
pub fn to_pretty_string(document: Value) -> String {
  write(document, True)
}

test "to_pretty_string indents by two spaces" {
  let document = Object([
    ("title", String("Dune")),
    ("tags", Array([String("classic"), Int(1)])),
    ("extra", Object([])),
    ("none", Array([])),
  ])
  let expected = string::join(
    [
      r"{",
      r#"  "title": "Dune","#,
      r#"  "tags": ["#,
      r#"    "classic","#,
      "    1",
      "  ],",
      r#"  "extra": {},"#,
      r#"  "none": []"#,
      r"}",
    ],
    "\n",
  )
  assert to_pretty_string(document) == expected
  assert to_pretty_string(Int(1)) == "1"
}

test "to_pretty_string puts each element on its own line at every depth" {
  let document = Array([
    Object([("a", Array([Int(1), Array([])])), ("b\"\n", Object([("c", Null)]))]),
    String("x\ny"),
    Float(float::neg_infinity),
  ])
  let expected = string::join(
    [
      "[",
      "  \{",
      r#"    "a": ["#,
      "      1,",
      "      []",
      "    ],",
      r#"    "b\"\n": {"#,
      r#"      "c": null"#,
      "    }",
      "  },",
      r#"  "x\ny","#,
      "  null",
      "]",
    ],
    "\n",
  )
  assert to_pretty_string(document) == expected
  assert to_string(document) == r#"[{"a":[1,[]],"b\"\n":{"c":null}},"x\ny",null]"#
  assert to_pretty_string(Array([])) == "[]"
  assert to_pretty_string(Object([])) == "\{}"
  assert to_pretty_string(String("a\tb")) == r#""a\tb""#
  assert to_pretty_string(Array([Null])) == "[\n  null\n]"
}

test "to_string escapes every control character, in keys too, and nothing else" {
  let assert Ok(controls) = string::from_code_point_values(lists::range(0, 32))
  let escaped = string::join(
    [
      r"\u0000\u0001\u0002\u0003\u0004\u0005\u0006\u0007",
      r"\b\t\n\u000b\f\r\u000e\u000f",
      r"\u0010\u0011\u0012\u0013\u0014\u0015\u0016\u0017",
      r"\u0018\u0019\u001a\u001b\u001c\u001d\u001e\u001f",
    ],
    "",
  )
  assert to_string(String(controls)) == "\"" + escaped + "\""
  // DEL, the C1 controls and the other non-ASCII code points stay as they
  // are, as `JSON.stringify` writes them.
  let kept = "\u{7F}\u{80}\u{9F}\u{A0}\u{2028}\u{2029}\u{FEFF}\u{10FFFF}/'<>&"
  assert to_string(String(kept)) == "\"" + kept + "\""
  assert to_string(String("")) == r#""""#
  let keys = Object([("a\"b\n", String("\\")), ("\u{1F}", Null)])
  assert to_string(keys) == r#"{"a\"b\n":"\\","\u001f":null}"#
}

test "to_string writes each float as float::show does" {
  let cases = [
    (0.1, "0.1"),
    (0.30000000000000004, "0.30000000000000004"),
    (100.0, "100.0"),
    (-2.5, "-2.5"),
    (123_456.789, "123456.789"),
    (0.001, "0.001"),
    (1.0e-5, "0.00001"),
    (1.0e-7, "1.0e-7"),
    (1.0e15, "1000000000000000.0"),
    (1.0e20, "100000000000000000000.0"),
    (1.5e300, "1.5e300"),
    (5.0e-324, "5.0e-324"),
  ]
  lists::each(cases, fn((x, text)) { assert (x, to_string(Float(x))) == (x, text) })
  let non_finite = Array([
    Float(float::nan),
    Float(float::neg_infinity),
    Float(float::infinity),
    Int(1),
  ])
  assert to_string(non_finite) == "[null,null,null,1]"
}

@target(native)
test "to_string writes any Int, and one outside the safe range reads back as a Float" {
  let document = Array([Int(int::max_safe + 2), Int(int::min_value), Int(int::max_safe)])
  let text = to_string(document)
  assert text == "[9007199254740993,-9223372036854775808,9007199254740991]"
  let floats = Array([
    Float(9_007_199_254_740_992.0),
    Float(-9_223_372_036_854_775_808.0),
    Int(int::max_safe),
  ])
  assert parse_value(text) == Ok(floats)
}

/// The open arrays and objects, innermost first: the elements or members
/// of each still to write, and the depth of nesting they are at. `Done`
/// stands outside the document's value. It is a chain of cells rather
/// than a list, so moving on to the next element writes the innermost cell
/// over in place (D-838).
priv type Open {
  Done,
  Items(List<Value>, Int, Open),
  Members(List<(String, Value)>, Int, Open),
}

/// Writes `document` as text, indented when `pretty` is `True`. The open arrays
/// and objects are a chain of cells on the heap, and every piece is added
/// to the end of one string, which no other value refers to, so each
/// addition extends it in place (D-577).
priv fn write(document: Value, pretty: Bool) -> String {
  write_value("", document, 0, pretty, Done)
}

/// Adds `node`, at `depth`, to `out`, then goes on with `open`.
priv fn write_value(out: String, node: Value, depth: Int, pretty: Bool, open: Open) -> String {
  case node {
    Null => next(out + "null", open, pretty)
    Bool(True) => next(out + "true", open, pretty)
    Bool(False) => next(out + "false", open, pretty)
    Int(n) => next(out + int::show(n), open, pretty)
    Float(x) => next(out + float_text(x), open, pretty)
    String(text) => next(string::add_json_quoted(out, text), open, pretty)
    Array([]) => next(out + "[]", open, pretty)
    Array([item, ..items]) => {
      let inner = depth + 1
      let opened = line_break(out + "[", pretty, inner)
      write_value(opened, item, inner, pretty, Items(items, inner, open))
    }
    Object([]) => next(out + "\{}", open, pretty)
    Object([(key, item), ..members]) => {
      let inner = depth + 1
      let opened = key_into(line_break(out + "\{", pretty, inner), key, pretty)
      write_value(opened, item, inner, pretty, Members(members, inner, open))
    }
  }
}

/// Goes on after a value: adds the next element or member of the innermost
/// open array or object, or its closing bracket.
///
/// The arm that takes the innermost cell apart builds the cell for the rest
/// of its elements, so Perceus writes it over the old one in place (D-838).
/// Keep the rebuild in that arm. Reuse pairs only when the rebuild is in a
/// block that only the block taking the cell apart enters (D-839). A
/// `let x = case ..` between the two, such as a `case pretty` that picks the
/// separator, joins the arms, and then the old cell is freed and a new one
/// allocated: the output stays the same, and nothing warns. The test
/// `json_containers_reuse_their_cells` in `crates/cheby_cli/tests/run.rs`
/// counts the reuse hits of a write, and fails when this step loses its
/// reuse.
priv fn next(out: String, open: Open, pretty: Bool) -> String {
  case open {
    Done => out
    Items([], depth, below) => next(line_break(out, pretty, depth - 1) + "]", below, pretty)
    Items([item, ..items], depth, below) => {
      let separated = line_break(out + ",", pretty, depth)
      write_value(separated, item, depth, pretty, Items(items, depth, below))
    }
    Members([], depth, below) => next(line_break(out, pretty, depth - 1) + "}", below, pretty)
    Members([(key, item), ..members], depth, below) => {
      let separated = key_into(line_break(out + ",", pretty, depth), key, pretty)
      write_value(separated, item, depth, pretty, Members(members, depth, below))
    }
  }
}

/// Adds the key of a member and the colon after it to `out`.
priv fn key_into(out: String, key: String, pretty: Bool) -> String {
  let quoted = string::add_json_quoted(out, key)
  case pretty {
    True => quoted + ": "
    False => quoted + ":"
  }
}

/// Adds a line ending and the indentation of `depth` to `out`, or nothing
/// when the text is compact.
priv fn line_break(out: String, pretty: Bool, depth: Int) -> String {
  case pretty {
    True => out + "\n" + string::repeat("  ", depth)
    False => out
  }
}

/// Writes a finite float as `float::show` does, and `null` for NaN and the
/// infinities, so encoding never fails (D-325).
priv fn float_text(x: Float) -> String {
  case float::is_finite(x) {
    True => float::show(x)
    False => "null"
  }
}

// Parsing

/// Parses `text` as `parse_value` does, then decodes the value with
/// `decoder` as `decode_value` does (D-320). The decoder runs only on JSON
/// text, and its errors come in the order it visited the values (D-322).
pub fn parse<T>(text: String, decoder: decode::Decoder<T>) -> Result<T, Error> {
  case tree::parse(text) {
    Ok(document) => case decode::run(decoder, document) {
      Ok(decoded) => Ok(decoded)
      Err(errors) => Err(Decode(errors))
    }
    Err((line, column)) => Err(Syntax(Position { line, column }))
  }
}

test "parse decodes a document in one step" {
  fn point() -> decode::Decoder<(Int, Int)> {
    use x <- decode::field("x", decode::int())
    use y <- decode::field("y", decode::int())
    decode::success((x, y))
  }
  assert parse(r#"{"x": 1, "y": 2}"#, point()) == Ok((1, 2))
  let x_problem = decode::Error { expected: "Int", found: "String", path: ["x"] }
  let y_problem = decode::Error { expected: "Int", found: "Null", path: ["y"] }
  assert parse(r#"{"x": "1", "y": null}"#, point()) == Err(Decode([x_problem, y_problem]))
  assert parse(r#"{"x": 1"#, point()) == Err(Syntax(Position { line: 1, column: 8 }))
}

/// Parses `text` as one JSON value with optional whitespace around it, and
/// returns it without decoding (D-321). A number without `.` or an exponent
/// is an `Int` when it lies within ±(2⁵³−1), and every other number is a
/// `Float` (D-217, D-222, D-394). A syntax error gives the position at
/// which `text` stops being JSON (D-324, D-326).
pub fn parse_value(text: String) -> Result<Value, Error> {
  let builder = tree::Builder {
    null: Null,
    bool: Bool,
    int: Int,
    float: Float,
    string: String,
    array: Array,
    object: Object,
  }
  case tree::parse_with(text, builder) {
    Ok(document) => Ok(document)
    Err((line, column)) => Err(Syntax(Position { line, column }))
  }
}

test "parse_value keeps integers and floats apart" {
  assert parse_value("1965") == Ok(Int(1965))
  assert parse_value("-0") == Ok(Int(0))
  assert parse_value("2.0") == Ok(Float(2.0))
  assert parse_value("1e3") == Ok(Float(1000.0))
  assert parse_value("9007199254740991") == Ok(Int(9_007_199_254_740_991))
  assert parse_value("9007199254740992") == Ok(Float(9_007_199_254_740_992.0))
  assert Int(1) != Float(1.0)
}

test "parse_value keeps object members in order, repeated keys too" {
  let assert Ok(first) = parse_value(r#"{"b": 1, "a": [true, null]}"#)
  assert first == Object([("b", Int(1)), ("a", Array([Bool(True), Null]))])
  let assert Ok(reordered) = parse_value(r#"{"a": [true, null], "b": 1}"#)
  assert first != reordered
  let twice = Object([("a", Int(1)), ("a", Int(2))])
  assert parse_value(r#"{"a": 1, "a": 2}"#) == Ok(twice)
}

test "parse_value reads escapes and rejects unpaired surrogates" {
  assert parse_value(r#""tab\t\u00e9 \ud83d\ude00""#) == Ok(String("tab\té \u{1F600}"))
  assert parse_value(r#""\ud800""#) == Err(Syntax(Position { line: 1, column: 8 }))
}

test "a syntax error gives the line and the column in code points" {
  let lf = string::join([r#"{"a": 1,"#, r#" "b" 2}"#], "\n")
  let crlf = string::join([r#"{"a": 1,"#, r#" "b" 2}"#], "\r\n")
  let colon_missing = Syntax(Position { line: 2, column: 6 })
  assert parse_value(lf) == Err(colon_missing)
  assert parse_value(crlf) == Err(colon_missing)
  assert parse_value(r#"["é", x]"#) == Err(Syntax(Position { line: 1, column: 7 }))
  assert parse_value("[1, 2,]") == Err(Syntax(Position { line: 1, column: 7 }))
  assert parse_value("1 2") == Err(Syntax(Position { line: 1, column: 3 }))
  assert parse_value("") == Err(Syntax(Position { line: 1, column: 1 }))
}

test "parse_value accepts any nesting depth" {
  let deep = string::repeat("[", 100_000) + string::repeat("]", 100_000)
  assert result::is_ok(parse_value(deep))
}

test "parse_value rounds numbers beyond the range of Float" {
  assert parse_value("1e400") == Ok(Float(float::infinity))
  assert parse_value("-1e400") == Ok(Float(float::neg_infinity))
}

// The tests below pin the parser's results and error positions on the
// edges of the grammar. Each table pairs a text with what `parse_value`
// gives for it, and a failed assertion shows the text.

test "parse_value reads numbers at the edges of Int and Float" {
  let cases = [
    ("0", Int(0)),
    ("-0", Int(0)),
    ("-1", Int(-1)),
    ("1.5", Float(1.5)),
    ("0.1", Float(0.1)),
    ("1e+5", Float(100_000.0)),
    ("1E+2", Float(100.0)),
    ("1E-2", Float(0.01)),
    ("-1.25e3", Float(-1250.0)),
    ("0.5e-3", Float(0.0005)),
    ("123.456e-2", Float(1.23456)),
    ("123456789012345", Int(123_456_789_012_345)),
    ("1234567890123456", Int(1_234_567_890_123_456)),
    ("-1234567890123456", Int(-1_234_567_890_123_456)),
    ("9007199254740991", Int(9_007_199_254_740_991)),
    ("-9007199254740991", Int(-9_007_199_254_740_991)),
    ("9007199254740992", Float(9_007_199_254_740_992.0)),
    ("-9007199254740992", Float(-9_007_199_254_740_992.0)),
    ("10000000000000000", Float(10_000_000_000_000_000.0)),
    ("12345678901234567890", Float(12_345_678_901_234_567_890.0)),
    ("1e400", Float(float::infinity)),
    ("-1e400", Float(float::neg_infinity)),
    ("[9007199254740991, -0]", Array([Int(9_007_199_254_740_991), Int(0)])),
  ]
  lists::each(cases, fn((text, want)) { assert (text, parse_value(text)) == (text, Ok(want)) })
  // `==` does not tell zeros apart, so their signs are read from the text.
  fn written(text: String) -> String {
    let assert Ok(document) = parse_value(text)
    to_string(document)
  }
  assert written("-0.0") == "-0.0"
  assert written("1e-400") == "0.0"
  assert written("-1e-400") == "-0.0"
}

test "a malformed number is an error at the first code point that cannot continue it" {
  let cases = [
    ("-", 1, 2),
    ("--1", 1, 2),
    ("-a", 1, 2),
    ("01", 1, 2),
    ("1.", 1, 3),
    ("1e", 1, 3),
    ("1e+", 1, 4),
    ("1e5x", 1, 4),
    ("[-]", 1, 3),
    ("[-a]", 1, 3),
    ("[1.e5]", 1, 4),
    ("[1e5.]", 1, 5),
    ("[1.5e]", 1, 6),
    ("[.5]", 1, 2),
    ("[+1]", 1, 2),
    ("[0x10]", 1, 3),
    ("[00]", 1, 3),
    ("[-01]", 1, 4),
  ]
  lists::each(cases, fn((text, line, column)) {
    assert (text, parse_value(text)) == (text, Err(Syntax(Position { line, column })))
  })
}

test "parse_value reads every escape and copies other code points" {
  let cases = [
    (r#""a\"b\\c\/d\b\f\n\r\t""#, "a\"b\\c/d\u{8}\u{C}\n\r\t"),
    (r#""\u0041\u00e9""#, "Aé"),
    (r#""\u0000\u001f\u007F\u0080\uFFFF""#, "\u{0}\u{1F}\u{7F}\u{80}\u{FFFF}"),
    (r#""\uD83D\uDE00\ud83d\ude00""#, "\u{1F600}\u{1F600}"),
    (r#""\udbff\udfff""#, "\u{10FFFF}"),
    ("\"é\u{1F600}\u{7F}\u{FFFF}\u{10FFFF}\"", "é\u{1F600}\u{7F}\u{FFFF}\u{10FFFF}"),
    (r#""""#, ""),
  ]
  lists::each(cases, fn((text, want)) {
    assert (text, parse_value(text)) == (text, Ok(String(want)))
  })
  let key = Object([("a\nb", String("/")), ("", Int(1))])
  assert parse_value(r#"{"a\nb": "\/", "": 1}"#) == Ok(key)
}

test "parse_value keeps a leading U+FEFF in keys, strings and runs before an escape" {
  let text = "\{\"\u{FEFF}\": [\"\u{FEFF}x\", \"\u{FEFF}\\n\"]}"
  let document = Object([("\u{FEFF}", Array([String("\u{FEFF}x"), String("\u{FEFF}\n")]))])
  assert parse_value(text) == Ok(document)
}

test "a bad escape is an error at the first code point that no escape could have" {
  let cases = [
    (r#""\q""#, 1, 3),
    ("\"\\é\"", 1, 3),
    (r#""\U0041""#, 1, 3),
    (r#""\u12G4""#, 1, 6),
    (r#""\uD8""#, 1, 6),
    (r#""\u""#, 1, 4),
    // A high surrogate needs the escape of a low one right after it.
    (r#""\ud800""#, 1, 8),
    (r#""\ud800A""#, 1, 8),
    (r#""\ud800x""#, 1, 8),
    (r#""\ud800\x""#, 1, 9),
    (r#""\ud800\u0041""#, 1, 10),
    (r#""\ud800\ud800""#, 1, 11),
    (r#""\ud83d\uDBFF""#, 1, 11),
    (r#""\ud83d\ud""#, 1, 11),
    // A low surrogate on its own fails at its second digit.
    (r#""\udc00""#, 1, 5),
    (r#""\uDC00""#, 1, 5),
  ]
  lists::each(cases, fn((text, line, column)) {
    assert (text, parse_value(text)) == (text, Err(Syntax(Position { line, column })))
  })
}

test "parse_value reads arrays, objects and the whitespace around them" {
  let cases = [
    ("true", Bool(True)),
    ("false", Bool(False)),
    ("null", Null),
    (" [ 1 , 2 ] ", Array([Int(1), Int(2)])),
    ("\t1\r\n", Int(1)),
    ("[1] ", Array([Int(1)])),
    ("[true,false,null]", Array([Bool(True), Bool(False), Null])),
    (r"[[[[]]], {}, [{}]]", Array([Array([Array([Array([])])]), Object([]), Array([Object([])])])),
    (r#"{"a" : 1 , "b":[ ] }"#, Object([("a", Int(1)), ("b", Array([]))])),
    (
      r#"{"é": [1, {"x": null}], "é": []}"#,
      Object([("é", Array([Int(1), Object([("x", Null)])])), ("é", Array([]))]),
    ),
    (
      r#"{"a": true, "\u0062\n": [false, null]}"#,
      Object([("a", Bool(True)), ("b\n", Array([Bool(False), Null]))]),
    ),
  ]
  lists::each(cases, fn((text, want)) { assert (text, parse_value(text)) == (text, Ok(want)) })
}

test "parse_value rejects what RFC 8259 does not allow where it starts" {
  let cases = [
    ("1 2", 1, 3),
    ("[1 2]", 1, 4),
    ("[1]x", 1, 4),
    ("[1]]", 1, 4),
    ("[1, 2,]", 1, 7),
    ("[1,,2]", 1, 4),
    ("[,1]", 1, 2),
    (r#"{"a" 1}"#, 1, 6),
    (r#"{"a": 1,}"#, 1, 9),
    (r#"{"a":}"#, 1, 6),
    (r"{,}", 1, 2),
    (r"{1: 2}", 1, 2),
    ("truex", 1, 5),
    ("nulL", 1, 4),
    ("fxlse", 1, 2),
    ("[tRue]", 1, 3),
    ("[1, nulx]", 1, 8),
    ("NaN", 1, 1),
    ("'a'", 1, 1),
    (r#"["é", x]"#, 1, 7),
    // Control characters must be escaped in strings.
    ("\"a\u{1}b\"", 1, 3),
    ("\"a\nb\"", 1, 3),
    ("\"\u{7F}\u{1F}\"", 1, 3),
    // Only space, tab, line feed and carriage return are whitespace, and
    // there is no byte order mark.
    ("\u{FEFF}1", 1, 1),
    ("\u{C}1", 1, 1),
    ("\u{A0}1", 1, 1),
  ]
  lists::each(cases, fn((text, line, column)) {
    assert (text, parse_value(text)) == (text, Err(Syntax(Position { line, column })))
  })
}

test "a syntax error counts lines at line feeds and columns in code points" {
  let cases = [
    ("\n\n  é  ", 3, 3),
    ("\r\n[\r\n1\r\n]x", 4, 2),
    (r#"["😀😀", ]"#, 1, 8),
    ("[\"\u{10FFFF}\", ]", 1, 7),
    ("é1", 1, 1),
    (r#"{"é": 1,"# + "\n" + r#" "b" 2}"#, 2, 6),
  ]
  lists::each(cases, fn((text, line, column)) {
    assert (text, parse_value(text)) == (text, Err(Syntax(Position { line, column })))
  })
}

test "a text that ends too early is an error just after its end" {
  let cases = [
    ("", 1, 1),
    ("  ", 1, 3),
    ("[", 1, 2),
    ("\{", 1, 2),
    ("[1,", 1, 4),
    ("[1,2", 1, 5),
    ("[\n1,\n", 3, 1),
    (r#"{"a""#, 1, 5),
    (r#"{"a":1,"#, 1, 8),
    (r#""abc"#, 1, 5),
    ("tru", 1, 4),
    ("nul", 1, 4),
    ("fals", 1, 5),
    ("-", 1, 2),
    (r#""\"#, 1, 3),
    (r#""\u12"#, 1, 6),
    (r#""\ud83d"#, 1, 8),
    (r#""\ud83d\ude0"#, 1, 13),
  ]
  lists::each(cases, fn((text, line, column)) {
    assert (text, parse_value(text)) == (text, Err(Syntax(Position { line, column })))
  })
}

test "parsing, writing and decode_value's conversion keep the stack flat at any depth" {
  fn nest(node: Value, level: Int, wrap: fn(Value) -> Value) -> Value {
    case level {
      0 => node
      _ => nest(wrap(node), level - 1, wrap)
    }
  }
  let depth = 100_000
  let arrays = nest(Null, depth, fn(inner) { Array([inner]) })
  let text = string::repeat("[", depth) + "null" + string::repeat("]", depth)
  assert to_string(arrays) == text
  let assert Ok(parsed) = parse_value(text)
  assert to_string(parsed) == text
  // success ignores its input, so these two check only the parse and
  // decode_value's conversion to the raw tree at depth (D-361).
  assert parse(text, decode::success(0)) == Ok(0)
  assert decode_value(arrays, decode::success(0)) == Ok(0)
  let open = string::repeat("[", depth)
  assert parse_value(open) == Err(Syntax(Position { line: 1, column: depth + 1 }))
  assert parse_value(open + "x") == Err(Syntax(Position { line: 1, column: depth + 1 }))
  let objects = nest(Int(1), 10_000, fn(inner) { Object([("a", Array([inner]))]) })
  let object_text = string::repeat(r#"{"a":["#, 10_000) + "1" + string::repeat("]}", 10_000)
  assert parse_value(object_text) == Ok(objects)
  assert to_string(objects) == object_text
  // Pretty text grows with the square of the depth, so it is checked less deep.
  let pretty = nest(Int(1), 1000, fn(inner) { Object([("a", Array([inner]))]) })
  let pretty_text = to_pretty_string(pretty)
  assert lists::length(string::split(pretty_text, "\n")) == 4001
  assert parse_value(pretty_text) == Ok(pretty)
}

/// Runs `decoder` on a value already parsed or built in the program, with
/// paths starting at `document` itself (D-361).
pub fn decode_value<T>(
  document: Value,
  decoder: decode::Decoder<T>,
) -> Result<T, List<decode::Error>> {
  decode::run(decoder, tree::rebuild(document, open_value, tree::Array, tree::Object))
}

test "decode_value decodes a value built in the program" {
  fn year() -> decode::Decoder<Int> {
    use found <- decode::field("year", decode::int())
    decode::success(found)
  }
  assert decode_value(Object([("year", Int(1965))]), year()) == Ok(1965)
  let problem = decode::Error { expected: "Int", found: "Float", path: ["year"] }
  assert decode_value(Object([("year", Float(1965.0))]), year()) == Err([problem])
}

/// Takes a `Value` apart, for `tree::rebuild`.
priv fn open_value(node: Value) -> tree::Children<Value, tree::Tree> {
  case node {
    Null => tree::Leaf(tree::Null)
    Bool(flag) => tree::Leaf(tree::Bool(flag))
    Int(n) => tree::Leaf(tree::Int(n))
    Float(x) => tree::Leaf(tree::Float(x))
    String(text) => tree::Leaf(tree::String(text))
    Array(items) => tree::Items(items)
    Object(members) => tree::Members(members)
  }
}

/// A decoder that accepts every JSON value and gives it as a `Value`, with
/// `Null` as its placeholder (D-1087). `std::json::decode` cannot name
/// `Value` (D-145, D-361), so it is declared here, as a primitive decoder
/// whose result is the decoded tree rebuilt as a `Value`, the mirror of
/// `decode_value`'s conversion (D-483).
pub fn value() -> decode::Decoder<Value> {
  decode::Leaf("Value", Null, fn(_) { True }, to_value)
}

/// Rebuilds a decoded tree as a `Value`, for `value`.
priv fn to_value(document: tree::Tree) -> Value {
  tree::rebuild(document, open_tree, Array, Object)
}

/// Takes a tree apart, for `tree::rebuild`: the mirror of `open_value`.
priv fn open_tree(node: tree::Tree) -> tree::Children<tree::Tree, Value> {
  case node {
    tree::Null => tree::Leaf(Null)
    tree::Bool(flag) => tree::Leaf(Bool(flag))
    tree::Int(n) => tree::Leaf(Int(n))
    tree::Float(x) => tree::Leaf(Float(x))
    tree::String(text) => tree::Leaf(String(text))
    tree::Array(items) => tree::Items(items)
    tree::Object(members) => tree::Members(members)
  }
}

test "value keeps any part of a document" {
  fn event() -> decode::Decoder<(String, Value)> {
    use kind <- decode::field("kind", decode::string())
    use data <- decode::field("data", value())
    decode::success((kind, data))
  }
  let text = r#"{"kind": "click", "data": {"x": 1, "tags": [true, null]}}"#
  let tags = Array([Bool(True), Null])
  let data = Object([("x", Int(1)), ("tags", tags)])
  assert parse(text, event()) == Ok(("click", data))
}

test "value gives Null for a missing field and accepts every kind" {
  fn extra() -> decode::Decoder<Value> {
    use found <- decode::field("extra", value())
    decode::success(found)
  }
  let missing = decode::Error { expected: "Field", found: "Nothing", path: ["extra"] }
  assert parse(r"{}", extra()) == Err(Decode([missing]))
  let texts = ["null", "false", "-7", "2.5", r#""é""#, r"[[], {}]", r#"{"a": {"a": [1]}, "a": 2}"#]
  lists::each(texts, fn(text) {
    let assert Ok(expected) = parse_value(text)
    assert (text, parse(text, value())) == (text, Ok(expected))
  })
  assert parse(r"[1, {}]", decode::list(value())) == Ok([Int(1), Object([])])
  let built = Array([Float(1.5), Object([("k", String("v"))])])
  assert decode_value(built, value()) == Ok(built)
}

test "value rebuilds a deep document without growing the stack" {
  let depth = 100_000
  let text = string::repeat("[", depth) + "null" + string::repeat("]", depth)
  let assert Ok(decoded) = parse(text, value())
  assert to_string(decoded) == text
}

// Errors

/// Writes `invalid JSON at line L, column C` for `Syntax`, and `unexpected
/// JSON: ` followed by each decode error's `show`, separated by `; `, for
/// `Decode` (D-400). It makes `Error` satisfy `Show`.
pub fn show(error: Error) -> String {
  case error {
    Syntax(Position { line, column }) => "invalid JSON at line {line}, column {column}"
    Decode(errors) => {
      let joined = string::join(lists::map(errors, decode::show), "; ")
      "unexpected JSON: {joined}"
    }
  }
}

test "a json error shows as a message" {
  let syntax = Syntax(Position { line: 2, column: 6 })
  assert show(syntax) == "invalid JSON at line 2, column 6"
  let year = decode::Error { expected: "Int", found: "String", path: ["year"] }
  let edition = decode::Error {
    expected: "Format",
    found: "String",
    path: ["books", "1", "format"],
  }
  let wrong = Decode([year, edition])
  assert "{wrong}" ==
    "unexpected JSON: expected Int, found String at year; expected Format, found String at books.1.format"
}

// Tests of `std::json::decode` that need this module.

test "every value that does not fit is reported, in the order visited" {
  fn pair() -> decode::Decoder<(String, Int)> {
    use name <- decode::field("name", decode::string())
    use year <- decode::field("year", decode::int())
    decode::success((name, year))
  }
  let name_problem = decode::Error { expected: "String", found: "Int", path: ["name"] }
  let year_problem = decode::Error { expected: "Field", found: "Nothing", path: ["year"] }
  let text = r#"{"year_of_birth": 1920, "name": 42}"#
  assert parse(text, pair()) == Err(Decode([name_problem, year_problem]))
}

test "string accepts only a JSON string" {
  assert parse(r#""Dune""#, decode::string()) == Ok("Dune")
  let problem = decode::Error { expected: "String", found: "Null", path: [] }
  assert parse("null", decode::string()) == Err(Decode([problem]))
}

test "int accepts only numbers read as integers" {
  assert parse("1965", decode::int()) == Ok(1965)
  let float_problem = decode::Error { expected: "Int", found: "Float", path: [] }
  assert parse("1965.0", decode::int()) == Err(Decode([float_problem]))
  assert parse("1e3", decode::int()) == Err(Decode([float_problem]))
  assert parse("9007199254740992", decode::int()) == Err(Decode([float_problem]))
}

test "float accepts any JSON number" {
  assert parse("2.5", decode::float()) == Ok(2.5)
  assert parse("2", decode::float()) == Ok(2.0)
  let problem = decode::Error { expected: "Float", found: "String", path: [] }
  assert parse(r#""2.5""#, decode::float()) == Err(Decode([problem]))
}

test "bool accepts only true and false" {
  assert parse("true", decode::bool()) == Ok(True)
  let problem = decode::Error { expected: "Bool", found: "Int", path: [] }
  assert parse("1", decode::bool()) == Err(Decode([problem]))
}

test "list decodes every element and reports each that does not fit" {
  assert parse("[1, 2, 3]", decode::list(decode::int())) == Ok([1, 2, 3])
  let second = decode::Error { expected: "Int", found: "String", path: ["1"] }
  let fourth = decode::Error { expected: "Int", found: "Null", path: ["3"] }
  let text = r#"[1, "two", 3, null]"#
  assert parse(text, decode::list(decode::int())) == Err(Decode([second, fourth]))
  let not_array = decode::Error { expected: "Array", found: "Object", path: [] }
  assert parse(r"{}", decode::list(decode::int())) == Err(Decode([not_array]))
}

test "optional turns null into None" {
  assert parse("null", decode::optional(decode::int())) == Ok(None)
  assert parse("5", decode::optional(decode::int())) == Ok(Some(5))
  let problem = decode::Error { expected: "Int", found: "String", path: [] }
  assert parse(r#""5""#, decode::optional(decode::int())) == Err(Decode([problem]))
}

test "pairs decodes an object with any keys, in order" {
  let text = r#"{"en": "one", "fr": "un", "en": "uno"}"#
  let words = [("en", "one"), ("fr", "un"), ("en", "uno")]
  assert parse(text, decode::pairs(decode::string())) == Ok(words)
  let problem = decode::Error { expected: "String", found: "Int", path: ["fr"] }
  let wrong = r#"{"en": "one", "fr": 1}"#
  assert parse(wrong, decode::pairs(decode::string())) == Err(Decode([problem]))
}

test "field reads a member and passes it on" {
  fn year() -> decode::Decoder<Int> {
    use found <- decode::field("year", decode::int())
    decode::success(found)
  }
  assert parse(r#"{"title": "Dune", "year": 1965}"#, year()) == Ok(1965)
  assert parse(r#"{"year": 1, "year": 2}"#, year()) == Ok(2)
  let missing = decode::Error { expected: "Field", found: "Nothing", path: ["year"] }
  assert parse(r#"{"title": "Dune"}"#, year()) == Err(Decode([missing]))
}

test "fields of nested objects add to the path" {
  fn author_name() -> decode::Decoder<String> {
    use name <- decode::field("author", decode::field("name", decode::string(), decode::success))
    decode::success(name)
  }
  assert parse(r#"{"author": {"name": "Toni Morrison"}}"#, author_name()) == Ok("Toni Morrison")
  let problem = decode::Error { expected: "String", found: "Int", path: ["author", "name"] }
  assert parse(r#"{"author": {"name": 42}}"#, author_name()) == Err(Decode([problem]))
}

test "a value that is not an object is reported once" {
  fn point() -> decode::Decoder<(Int, Int)> {
    use x <- decode::field("x", decode::int())
    use y <- decode::field("y", decode::int())
    decode::success((x, y))
  }
  let problem = decode::Error { expected: "Object", found: "Array", path: [] }
  assert parse("[1, 2]", point()) == Err(Decode([problem]))
}

test "optional_field handles a missing key, and optional handles null" {
  fn born() -> decode::Decoder<Option<Int>> {
    use year <- decode::optional_field("born", None, decode::optional(decode::int()))
    decode::success(year)
  }
  assert parse(r#"{"name": "Homer"}"#, born()) == Ok(None)
  assert parse(r#"{"name": "Homer", "born": null}"#, born()) == Ok(None)
  assert parse(r#"{"name": "Frank Herbert", "born": 1920}"#, born()) == Ok(Some(1920))
}

test "optional_field passes null to its decoder" {
  fn tags() -> decode::Decoder<List<String>> {
    use found <- decode::optional_field("tags", [], decode::list(decode::string()))
    decode::success(found)
  }
  assert parse(r"{}", tags()) == Ok([])
  let problem = decode::Error { expected: "Array", found: "Null", path: ["tags"] }
  assert parse(r#"{"tags": null}"#, tags()) == Err(Decode([problem]))
}

test "then chooses the next decoder from a decoded value" {
  fn shape() -> decode::Decoder<Float> {
    use kind <- decode::then(decode::field("type", decode::string(), decode::success))
    case kind {
      "circle" => decode::field("radius", decode::float(), decode::success)
      "square" => decode::field("side", decode::float(), decode::success)
      _ => decode::failure(0.0, "Shape")
    }
  }
  assert parse(r#"{"type": "circle", "radius": 1.5}"#, shape()) == Ok(1.5)
  let unknown = decode::Error { expected: "Shape", found: "Object", path: [] }
  assert parse(r#"{"type": "star"}"#, shape()) == Err(Decode([unknown]))
  let not_string = decode::Error { expected: "String", found: "Int", path: ["type"] }
  assert parse(r#"{"type": 3}"#, shape()) == Err(Decode([not_string]))
}

test "map changes the decoded value" {
  let length = decode::map(decode::string(), string::length)
  assert parse(r#""Dune""#, length) == Ok(4)
  let problem = decode::Error { expected: "String", found: "Bool", path: [] }
  assert parse("false", length) == Err(Decode([problem]))
}

test "success gives its value whatever the input" {
  assert parse("null", decode::success(7)) == Ok(7)
  assert parse(r#"{"a": [1]}"#, decode::success("done")) == Ok("done")
}

test "failure reports what was expected" {
  fn even() -> decode::Decoder<Int> {
    use n <- decode::then(decode::int())
    case n % 2 {
      0 => decode::success(n)
      _ => decode::failure(0, "EvenInt")
    }
  }
  assert parse("[2, 4]", decode::list(even())) == Ok([2, 4])
  let problem = decode::Error { expected: "EvenInt", found: "Int", path: ["1"] }
  assert parse("[2, 3]", decode::list(even())) == Err(Decode([problem]))
}

test "lazy lets a decoder refer to itself" {
  fn size() -> decode::Decoder<Int> {
    let children = decode::list(decode::lazy(0, size))
    decode::map(children, fn(sizes) { lists::fold(sizes, 1, int::add) })
  }
  assert parse("[[], [[]]]", size()) == Ok(4)
  let problem = decode::Error { expected: "Array", found: "Int", path: ["1", "0"] }
  assert parse("[[], [3]]", size()) == Err(Decode([problem]))
}

test "a lazy decoder's placeholder stands in for a missing field" {
  fn depth() -> decode::Decoder<Int> {
    use kind <- decode::field("kind", decode::string())
    case kind {
      "leaf" => decode::success(0)
      _ => decode::field("child", decode::lazy(0, depth), fn(d) { decode::success(d + 1) })
    }
  }
  assert parse(r#"{"kind": "node", "child": {"kind": "leaf"}}"#, depth()) == Ok(1)
  let missing = decode::Error { expected: "Field", found: "Nothing", path: ["child"] }
  assert parse(r#"{"kind": "node"}"#, depth()) == Err(Decode([missing]))
}

test "one_of takes the first decoder that fits" {
  let id = decode::one_of(decode::map(decode::int(), int::show), [decode::string()])
  assert parse("7", id) == Ok("7")
  assert parse(r#""a1""#, id) == Ok("a1")
  let problem = decode::Error { expected: "Int", found: "Bool", path: [] }
  assert parse("true", id) == Err(Decode([problem]))
}

test "at reads a member through nested objects" {
  let name = decode::at(["author", "name"], decode::string())
  assert parse(r#"{"author": {"name": "Toni Morrison"}}"#, name) == Ok("Toni Morrison")
  let missing = decode::Error { expected: "Field", found: "Nothing", path: ["author", "name"] }
  assert parse(r#"{"author": {}}"#, name) == Err(Decode([missing]))
}

// A tree of names and an expression, for the tests of `lazy` below. They
// are named in the tests, so user builds do not report them unused (D-631).
priv type Node {
  name: String,
  children: List<Node>,
}

priv type Expr {
  Lit(Int),
  Neg(Expr),
}

priv fn named_tree() -> decode::Decoder<Node> {
  let placeholder = Node { name: "", children: [] }
  use children <- decode::field("children", decode::list(decode::lazy(placeholder, named_tree)))
  use name <- decode::field("name", decode::string())
  decode::success(Node { name, children })
}

priv fn expression() -> decode::Decoder<Expr> {
  use op <- decode::field("op", decode::string())
  case op {
    "lit" => decode::field("value", decode::int(), fn(n) { decode::success(Lit(n)) })
    _ => decode::field("arg", decode::lazy(Lit(0), expression), fn(e) { decode::success(Neg(e)) })
  }
}

test "a recursive decoder whose first field recurses terminates with lazy" {
  // Without `lazy`, building `named_tree()` builds the decoder of `children`,
  // which builds `named_tree()` again, and overflows the stack (D-1086).
  let text = r#"{"children": [{"name": "b", "children": []}], "name": "a"}"#
  let leaf = Node { name: "b", children: [] }
  assert parse(text, named_tree()) == Ok(Node { name: "a", children: [leaf] })
  fn height(tree_node: Node) -> Int {
    case tree_node.children {
      [child] => 1 + height(child)
      _ => 0
    }
  }
  let open = r#"{"name": "n", "children": ["#
  let leaf_text = r#"{"name": "leaf", "children": []}"#
  let deep = string::repeat(open, 100) + leaf_text + string::repeat("]}", 100)
  let assert Ok(top) = parse(deep, named_tree())
  assert height(top) == 100
}

test "a recursion reached on a missing field stops at lazy's placeholder" {
  // A placeholder made by running `expression()` on `null` would read `op` as
  // `""` and reach `arg` again forever (D-401, D-1086).
  let good = r#"{"op": "neg", "arg": {"op": "lit", "value": 3}}"#
  assert parse(good, expression()) == Ok(Neg(Lit(3)))
  let missing = decode::Error { expected: "Field", found: "Nothing", path: ["arg"] }
  assert parse(r#"{"op": "neg"}"#, expression()) == Err(Decode([missing]))
  let not_object = decode::Error { expected: "Object", found: "Int", path: ["arg"] }
  assert parse(r#"{"op": "neg", "arg": 5}"#, expression()) == Err(Decode([not_object]))
}

// A decode error, for the tests below. It is named in them, so user builds
// do not report it unused (D-631).
priv fn mismatch(expected: String, found: String, path: List<String>) -> decode::Error {
  decode::Error { expected, found, path }
}

test "the errors of a list of records come in the order visited, with whole paths" {
  fn author() -> decode::Decoder<String> {
    use name <- decode::field("name", decode::string())
    decode::success(name)
  }
  fn book() -> decode::Decoder<(String, Int, String)> {
    use title <- decode::field("title", decode::string())
    use year <- decode::field("year", decode::int())
    use tags <- decode::field("tags", decode::list(decode::string()))
    use name <- decode::field("author", author())
    decode::success((title, year, string::join([name, ..tags], ", ")))
  }
  fn library() -> decode::Decoder<List<(String, Int, String)>> {
    use books <- decode::field("books", decode::list(book()))
    decode::success(books)
  }
  let dune = r#"  {"title": "Dune", "year": 1965, "tags": ["sf"], "author": {"name": "F. H."}}"#
  let one = r#"{"books": ["# + dune + "]}"
  assert parse(one, library()) == Ok([("Dune", 1965, "F. H., sf")])
  let text = string::join(
    [
      r#"{"books": ["#,
      dune + ",",
      r#"  {"title": 2, "year": "1966", "tags": ["sf", 3, null], "author": {"name": 4}},"#,
      r#"  {"tags": {}, "author": []},"#,
      "  7",
      "]}",
    ],
    "\n",
  )
  let errors = [
    mismatch("String", "Int", ["books", "1", "title"]),
    mismatch("Int", "String", ["books", "1", "year"]),
    mismatch("String", "Int", ["books", "1", "tags", "1"]),
    mismatch("String", "Null", ["books", "1", "tags", "2"]),
    mismatch("String", "Int", ["books", "1", "author", "name"]),
    mismatch("Field", "Nothing", ["books", "2", "title"]),
    mismatch("Field", "Nothing", ["books", "2", "year"]),
    mismatch("Array", "Object", ["books", "2", "tags"]),
    mismatch("Object", "Array", ["books", "2", "author"]),
    mismatch("Object", "Int", ["books", "3"]),
  ]
  let assert Err(error) = parse(text, library())
  assert error == Decode(errors)
  let shown = string::join(
    [
      "unexpected JSON: expected String, found Int at books.1.title",
      "expected Int, found String at books.1.year",
      "expected String, found Int at books.1.tags.1",
      "expected String, found Null at books.1.tags.2",
      "expected String, found Int at books.1.author.name",
      "expected Field, found Nothing at books.2.title",
      "expected Field, found Nothing at books.2.year",
      "expected Array, found Object at books.2.tags",
      "expected Object, found Array at books.2.author",
      "expected Object, found Int at books.3",
    ],
    "; ",
  )
  assert show(error) == shown
  let assert Ok(document) = parse_value(text)
  assert decode_value(document, library()) == Err(errors)
}

test "a missing or wrong field gives next its decoder's placeholder" {
  // `next` fails when it gets the placeholders, which shows what they are.
  fn checked() -> decode::Decoder<Int> {
    use title <- decode::field("title", decode::string())
    use born <- decode::field("born", decode::optional(decode::int()))
    use year <- decode::field("year", decode::float())
    use tags <- decode::field("tags", decode::list(decode::string()))
    case title, born, year, tags {
      "", None, zero, [] when zero == 0.0 => decode::failure(0, "Missing")
      "", Some(0), zero, [] when zero == 0.0 => decode::failure(0, "Wrong")
      _, _, _, _ => decode::success(1)
    }
  }
  let full = r#"{"title": "Dune", "born": 1920, "year": 1965, "tags": []}"#
  assert parse(full, checked()) == Ok(1)
  let missing = [
    mismatch("Field", "Nothing", ["title"]),
    mismatch("Field", "Nothing", ["born"]),
    mismatch("Field", "Nothing", ["year"]),
    mismatch("Field", "Nothing", ["tags"]),
    mismatch("Missing", "Object", []),
  ]
  assert parse(r#"{"other": 1}"#, checked()) == Err(Decode(missing))
  let wrong = [
    mismatch("String", "Int", ["title"]),
    mismatch("Int", "String", ["born"]),
    mismatch("Float", "Null", ["year"]),
    mismatch("Array", "Int", ["tags"]),
    mismatch("Wrong", "Object", []),
  ]
  let text = r#"{"title": 1, "born": "x", "year": null, "tags": 5}"#
  assert parse(text, checked()) == Err(Decode(wrong))
  let not_object = [mismatch("Object", "Bool", []), mismatch("Missing", "Bool", [])]
  assert parse("true", checked()) == Err(Decode(not_object))
}

test "optional_field gives its default for a missing key or a value that is not an object" {
  fn count() -> decode::Decoder<Int> {
    use n <- decode::optional_field("n", 5, decode::int())
    case n {
      5 => decode::failure(0, "Default")
      0 => decode::failure(0, "Placeholder")
      _ => decode::success(n)
    }
  }
  assert parse(r#"{"n": 7}"#, count()) == Ok(7)
  assert parse(r"{}", count()) == Err(Decode([mismatch("Default", "Object", [])]))
  let not_object = [mismatch("Object", "Array", []), mismatch("Default", "Array", [])]
  assert parse("[1]", count()) == Err(Decode(not_object))
  let wrong = [mismatch("Int", "String", ["n"]), mismatch("Placeholder", "Object", [])]
  assert parse(r#"{"n": "x"}"#, count()) == Err(Decode(wrong))
  let null = [mismatch("Int", "Null", ["n"]), mismatch("Placeholder", "Object", [])]
  assert parse(r#"{"n": null}"#, count()) == Err(Decode(null))
  assert parse(r#"{"n": "x", "n": 3}"#, count()) == Ok(3)
}

test "an error equal to one already recorded is dropped" {
  fn twice() -> decode::Decoder<(Int, Int)> {
    use a <- decode::field("a", decode::int())
    use b <- decode::field("a", decode::int())
    decode::success((a, b))
  }
  assert parse(r"{}", twice()) == Err(Decode([mismatch("Field", "Nothing", ["a"])]))
  assert parse(r#"{"a": "x"}"#, twice()) == Err(Decode([mismatch("Int", "String", ["a"])]))
  let ints = decode::pairs(decode::int())
  assert parse(r#"{"k": "x", "k": "y"}"#, ints) == Err(Decode([mismatch("Int", "String", ["k"])]))
  let two = [mismatch("Int", "String", ["k"]), mismatch("Int", "Null", ["k"])]
  assert parse(r#"{"k": "x", "j": 1, "k": null}"#, ints) == Err(Decode(two))
}

test "nested lists and pairs add each index and key to the path" {
  let grid = decode::list(decode::list(decode::int()))
  assert parse("[[1, 2], [], [3]]", grid) == Ok([[1, 2], [], [3]])
  let cells = [
    mismatch("Int", "String", ["0", "1"]),
    mismatch("Int", "String", ["1", "0"]),
    mismatch("Array", "Int", ["2"]),
  ]
  assert parse(r#"[[1, "a"], ["b"], 3]"#, grid) == Err(Decode(cells))
  let groups = decode::pairs(decode::list(decode::int()))
  let members = [
    mismatch("Int", "String", ["k", "1"]),
    mismatch("Array", "Int", [""]),
    mismatch("Int", "Bool", ["a.b", "0"]),
  ]
  let assert Err(error) = parse(r#"{"k": [1, "x"], "": 2, "a.b": [true]}"#, groups)
  assert error == Decode(members)
  let shown = string::join(
    [
      "unexpected JSON: expected Int, found String at k.1",
      "expected Array, found Int at ",
      "expected Int, found Bool at a.b.0",
    ],
    "; ",
  )
  assert show(error) == shown
}

test "float and int read the numbers parse_value reads" {
  assert parse("-9007199254740991", decode::float()) == Ok(-9_007_199_254_740_991.0)
  let floats = decode::list(decode::float())
  assert parse("[1, 2.5, -0, 1e400]", floats) == Ok([1.0, 2.5, 0.0, float::infinity])
  assert parse("-0", decode::int()) == Ok(0)
  assert parse("-9007199254740991", decode::int()) == Ok(-9_007_199_254_740_991)
  let problem = decode::Error { expected: "Int", found: "Float", path: [] }
  assert parse("-9007199254740992", decode::int()) == Err(Decode([problem]))
}

@target(native)
test "decode_value passes an Int outside the safe range to int and float" {
  assert decode_value(Int(int::max_safe + 2), decode::int()) == Ok(int::max_safe + 2)
  assert decode_value(Int(int::max_safe + 2), decode::float()) == Ok(9_007_199_254_740_992.0)
}
