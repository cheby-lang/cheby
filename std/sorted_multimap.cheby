//! The sorted multimap `SortedMultimap<K, V>`, a persistent map from each
//! key to a list of values, ordered by key (D-332, D-338), written in Cheby
//! over `std::sorted_map` with no runtime kernel (D-336).
//!
//! A multimap is a `SortedMap<K, List<V>>` with the total number of values
//! kept next to it, so `count` is O(1). A key is present only while it has
//! a value (D-364). Every function carries the bound `K: Compare` (D-385).
//! The hooks and `value_pairs` carry none, as D-482 asks of hooks, and reach the
//! tree only through `sorted_map`'s unbounded helpers
//! (D-845).

import std::int
import std::list
import std::ops::{Compare}
import std::set
import std::sorted_map

/// A persistent map from each key to its values in insertion order,
/// ordered by key (D-332, D-336, D-338, D-341). Equality, hashing and
/// debug printing go through `equal`, `hash` and `debug` (D-342).
@std_hooks(equal, hash, debug)
pub type SortedMultimap<K, V> {
  entries: sorted_map::SortedMap<K, List<V>>,
  total: Int,
}

/// One pair per value, in key order and, within a key, in insertion order,
/// without calling `compare` (the hooks and `to_pairs`).
/// It has no bound, as D-482 asks of hooks (D-845).
priv fn value_pairs<K, V>(m: SortedMultimap<K, V>) -> List<(K, V)> {
  sorted_map::fold_entries(m.entries, [], fn(found, key, values) {
    list::fold(values, found, fn(more, value) { list::push(more, (key, value)) })
  })
}

/// Whether two multimaps have the same keys, each with the same list of
/// values in the same order, compared with `==` (D-343).
fn equal<K, V>(a: SortedMultimap<K, V>, b: SortedMultimap<K, V>) -> Bool {
  a.total == b.total && sorted_map::entries(a.entries) == sorted_map::entries(b.entries)
}

/// The keys in order with their values: equal multimaps give equal lists
/// (D-584).
fn hash<K, V>(m: SortedMultimap<K, V>) -> List<(K, List<V>)> {
  sorted_map::entries(m.entries)
}

/// `sorted_multimap::from_list([…])` with one debug-printed pair per value,
/// in the order of `to_pairs`, so the text rebuilds the multimap (D-344).
fn debug<K, V>(m: SortedMultimap<K, V>) -> String {
  let items = value_pairs(m)
  "sorted_multimap::from_list({items:?})"
}

test "sorted multimaps compare, hash and print by contents" {
  let built = from_list([("b", 3), ("a", 1), ("a", 2)])
  let grown = insert(from_list([("a", 1), ("b", 3)]), "a", 2)
  assert built == grown
  assert built != from_list([("a", 2), ("a", 1), ("b", 3)])
  assert set::size(set::from_list([built, grown])) == 1
  assert "{built:?}" == "sorted_multimap::from_list([(\"a\", 1), (\"a\", 2), (\"b\", 3)])"
}

// Building

/// Returns an empty multimap.
pub fn new<K: Compare, V>() -> SortedMultimap<K, V> {
  SortedMultimap { entries: sorted_map::new(), total: 0 }
}

test "new is empty" {
  let empty = new::<String, Int>()
  assert is_empty(empty)
  assert to_list(empty) == []
}

/// Returns a multimap with every pair, as if each were inserted in turn.
/// No pair is dropped, so repeated pairs give repeated values.
pub fn from_list<K: Compare, V>(pairs: List<(K, V)>) -> SortedMultimap<K, V> {
  list::fold(pairs, new(), fn(m, (key, value)) { insert(m, key, value) })
}

test "from_list keeps every pair" {
  let tags = from_list([("b", 1), ("a", 2), ("b", 1)])
  assert to_list(tags) == [("a", [2]), ("b", [1, 1])]
}

// Size

/// Returns the number of keys, O(1). `count` returns the number of values
/// (D-363).
pub fn size<K: Compare, V>(m: SortedMultimap<K, V>) -> Int {
  sorted_map::size(m.entries)
}

test "size counts keys" {
  let tags = from_list([("a", 1), ("a", 2), ("b", 3)])
  assert size(tags) == 2
}

/// Returns the total number of values, over every key, O(1): the multimap
/// keeps the total next to its map (D-363).
pub fn count<K: Compare, V>(m: SortedMultimap<K, V>) -> Int {
  m.total
}

test "count counts values" {
  let tags = from_list([("a", 1), ("a", 2), ("b", 3)])
  assert count(tags) == 3
}

/// Tells whether the multimap has no keys, and so no values.
pub fn is_empty<K: Compare, V>(m: SortedMultimap<K, V>) -> Bool {
  sorted_map::is_empty(m.entries)
}

test "is_empty tells an empty multimap" {
  assert is_empty(new::<String, Int>())
  assert !is_empty(from_list([("a", 1)]))
}

// Lookup

/// Returns the values stored under the key that compares `Equal` to `key`,
/// in insertion order, or `[]` when there is no such key (D-364).
pub fn get<K: Compare, V>(m: SortedMultimap<K, V>, key: K) -> List<V> {
  case sorted_map::get(m.entries, key) {
    Some(values) => values
    None => []
  }
}

test "get returns every value of a key" {
  let tags = from_list([("a", 1), ("b", 3), ("a", 2)])
  assert get(tags, "a") == [1, 2]
  assert get(tags, "z") == []
}

/// Tells whether some key compares `Equal` to `key`.
pub fn has_key<K: Compare, V>(m: SortedMultimap<K, V>, key: K) -> Bool {
  sorted_map::has_key(m.entries, key)
}

test "has_key tells whether a key is present" {
  let tags = from_list([("a", 1)])
  assert has_key(tags, "a")
  assert !has_key(tags, "b")
}

/// Returns the smallest key with its values, or `None` when the multimap is
/// empty.
pub fn first<K: Compare, V>(m: SortedMultimap<K, V>) -> Option<(K, List<V>)> {
  sorted_map::first(m.entries)
}

test "first is the smallest key" {
  let tags = from_list([("b", 3), ("a", 1), ("a", 2)])
  assert first(tags) == Some(("a", [1, 2]))
  assert first(new::<String, Int>()) == None
}

/// Returns the largest key with its values, or `None` when the multimap is
/// empty.
pub fn last<K: Compare, V>(m: SortedMultimap<K, V>) -> Option<(K, List<V>)> {
  sorted_map::last(m.entries)
}

test "last is the largest key" {
  let tags = from_list([("b", 3), ("a", 1), ("b", 4)])
  assert last(tags) == Some(("b", [3, 4]))
  assert last(new::<String, Int>()) == None
}

/// Returns the keys that are at least `start` and less than `end`, each
/// with its values, in key order (D-319), in O(log n + k) for k keys
/// returned.
pub fn range<K: Compare, V>(m: SortedMultimap<K, V>, start: K, end: K) -> List<(K, List<V>)> {
  sorted_map::range(m.entries, start, end)
}

test "range includes start and excludes end" {
  let marks = from_list([(1, "a"), (3, "c"), (3, "C"), (5, "e")])
  assert range(marks, 2, 5) == [(3, ["c", "C"])]
  assert range(marks, 5, 2) == []
}

/// Returns the key at `index` in key order with its values, counting from
/// 0 and counting keys, as `size` does, or `None` outside 0 to `size - 1`
/// (D-318, D-363, D-1083): `sorted_map::at` on the tree, O(log n), with no
/// call to `compare`.
pub fn at<K: Compare, V>(m: SortedMultimap<K, V>, index: Int) -> Option<(K, List<V>)> {
  sorted_map::at(m.entries, index)
}

test "at counts keys from the smallest" {
  let marks = from_list([(3, "c"), (1, "a"), (3, "C")])
  assert at(marks, 0) == Some((1, ["a"]))
  assert at(marks, 1) == Some((3, ["c", "C"]))
  assert at(marks, 2) == None
  assert at(marks, -1) == None
}

// Updating

/// Returns the multimap with `value` appended to the values of `key`. When
/// a key that compares `Equal` to `key` is already present, the stored key
/// stays (D-341). One descent of the tree and one push onto the key's list:
/// O(log n + log m), where m is the number of values of the key
/// (D-846, as `multimap::insert` states).
pub fn insert<K: Compare, V>(m: SortedMultimap<K, V>, key: K, value: V) -> SortedMultimap<K, V> {
  // Taking the record apart first ends `m` before the tree changes, so a
  // multimap held only here reaches `upsert` unshared and its path can be
  // rebuilt in place (D-716).
  let SortedMultimap { entries, total } = m
  let grown = sorted_map::upsert(entries, key, fn(found) {
    case found {
      Some(values) => list::push(values, value)
      None => [value]
    }
  })
  SortedMultimap { entries: grown, total: total + 1 }
}

test "insert appends a value" {
  let start = from_list([("a", 1)])
  let again = insert(insert(start, "a", 1), "b", 2)
  assert to_list(again) == [("a", [1, 1]), ("b", [2])]
  assert get(start, "a") == [1]
}

// A key type for the next test, ordered by `id` alone. Two badges with the
// same `id` and different labels compare `Equal` without being `==`.
// Satisfaction is not a written use, so the test also names `compare`
// (D-631).
priv type Badge {
  id: Int,
  label: String,
}

priv fn compare(a: Badge, b: Badge) -> Order {
  int::compare(a.id, b.id)
}

test "values of keys that compare Equal share one list" {
  let stored = Badge { id: 1, label: "stored" }
  let later = Badge { id: 1, label: "later" }
  let badges = insert(from_list([(stored, "a")]), later, "b")
  assert to_list(badges) == [(stored, ["a", "b"])]
  assert get(badges, Badge { id: 1, label: "other" }) == ["a", "b"]
  assert compare(stored, later) == Equal
}

/// Returns the multimap without the key that compares `Equal` to `key` and
/// without all of its values, or unchanged when there is no such key.
pub fn remove<K: Compare, V>(m: SortedMultimap<K, V>, key: K) -> SortedMultimap<K, V> {
  case sorted_map::get(m.entries, key) {
    Some(values) => {
      // As in `insert`: `m` ends before the tree changes (D-716).
      let SortedMultimap { entries, total } = m
      SortedMultimap {
        entries: sorted_map::remove(entries, key),
        total: total - list::length(values),
      }
    }
    None => m
  }
}

test "remove drops a key with all its values" {
  let tags = from_list([("a", 1), ("a", 2), ("b", 3)])
  assert remove(tags, "a") == from_list([("b", 3)])
  assert remove(tags, "z") == tags
}

// Iterating

/// Returns the keys in order, each once.
pub fn keys<K: Compare, V>(m: SortedMultimap<K, V>) -> List<K> {
  sorted_map::keys(m.entries)
}

test "keys come in key order" {
  let tags = from_list([("b", 1), ("a", 2), ("b", 3)])
  assert keys(tags) == ["a", "b"]
}

/// Returns each key with its values, in key order.
pub fn to_list<K: Compare, V>(m: SortedMultimap<K, V>) -> List<(K, List<V>)> {
  sorted_map::to_list(m.entries)
}

test "to_list groups the values by key" {
  let tags = from_list([("b", 1), ("a", 2), ("b", 3)])
  assert to_list(tags) == [("a", [2]), ("b", [1, 3])]
}

/// Returns one pair per value, in key order and, within a key, in
/// insertion order, in O(n + t) for t values. `from_list(to_pairs(m))` is
/// `m`.
pub fn to_pairs<K: Compare, V>(m: SortedMultimap<K, V>) -> List<(K, V)> {
  value_pairs(m)
}

test "to_pairs gives one pair per value" {
  let tags = from_list([("b", 1), ("a", 2), ("b", 3)])
  assert to_pairs(tags) == [("a", 2), ("b", 1), ("b", 3)]
}

/// Combines the keys in order, starting from `initial` and calling `f` once
/// per key with all of its values.
pub fn fold<K: Compare, V, A>(m: SortedMultimap<K, V>, initial: A, f: fn(A, K, List<V>) -> A) -> A {
  sorted_map::fold(m.entries, initial, f)
}

test "fold visits each key once" {
  let tags = from_list([("b", 1), ("a", 2), ("b", 3)])
  let text = fold(tags, "", fn(acc, key, values) {
    let n = list::length(values)
    acc + "{key}{n}"
  })
  assert text == "a1b2"
}

/// Calls `f` once per key, in key order, with all of its values, for its
/// effects.
pub fn each<K: Compare, V>(m: SortedMultimap<K, V>, f: fn(K, List<V>)) {
  sorted_map::each(m.entries, f)
}

test "each sees every key with its values" {
  let tags = from_list([("a", 1), ("b", 2), ("b", 3)])
  each(tags, fn(_, values) { assert !list::is_empty(values) })
}

/// Combines the keys in order like `fold`, each with all of its values,
/// and stops at the first `Err` that `f` returns (D-1080, D-1082). It walks
/// the tree, so a walk that stops after k keys takes O(log n + k).
pub fn try_fold<K: Compare, V, A, E>(
  m: SortedMultimap<K, V>,
  initial: A,
  f: fn(A, K, List<V>) -> Result<A, E>,
) -> Result<A, E> {
  sorted_map::try_fold(m.entries, initial, f)
}

test "try_fold stops at the first error" {
  fn add_single(total: Int, key: String, values: List<Int>) -> Result<Int, String> {
    case values {
      [n] => Ok(total + n)
      _ => Err(key)
    }
  }
  let tags = from_list([("b", 1), ("a", 2), ("b", 3)])
  assert try_fold(tags, 0, add_single) == Err("b")
  assert try_fold(remove(tags, "b"), 0, add_single) == Ok(2)
  assert try_fold(new(), 7, add_single) == Ok(7)
  let stops = try_fold(tags, 0, fn(total, key, values) {
    case key {
      "b" => panic as "not reached"
      _ => Err(total + list::length(values))
    }
  })
  assert stops == Err(1)
}

/// Tells whether `predicate` returns `True` for some key with its values,
/// in key order, stopping at the first such key (D-1082).
pub fn any<K: Compare, V>(m: SortedMultimap<K, V>, predicate: fn(K, List<V>) -> Bool) -> Bool {
  sorted_map::any(m.entries, predicate)
}

test "any stops at the first matching key" {
  let tags = from_list([("a", 1), ("b", 2), ("b", 3), ("c", 4)])
  assert any(tags, fn(key, values) {
    case key {
      "c" => panic as "not reached"
      _ => list::length(values) > 1
    }
  })
  assert !any(tags, fn(key, _) { key == "d" })
  assert !any(new::<String, Int>(), fn(_, _) { True })
}

/// Tells whether `predicate` returns `True` for every key with its values,
/// in key order, stopping at the first key for which it returns `False`
/// (D-1082).
pub fn all<K: Compare, V>(m: SortedMultimap<K, V>, predicate: fn(K, List<V>) -> Bool) -> Bool {
  sorted_map::all(m.entries, predicate)
}

test "all needs every key to match" {
  let tags = from_list([("a", 1), ("b", 2), ("b", 3)])
  assert all(tags, fn(_, values) { !list::is_empty(values) })
  assert !all(tags, fn(_, values) { list::length(values) > 1 })
  assert all(new::<String, Int>(), fn(_, _) { False })
}

/// Returns the smallest key, with its values, for which `predicate`
/// returns `True`, stopping there (D-1082).
pub fn find<K: Compare, V>(
  m: SortedMultimap<K, V>,
  predicate: fn(K, List<V>) -> Bool,
) -> Option<(K, List<V>)> {
  sorted_map::find(m.entries, predicate)
}

test "find returns the first matching key in order" {
  let tags = from_list([("c", 4), ("b", 2), ("a", 1), ("b", 3)])
  assert find(tags, fn(key, _) { key > "a" }) == Some(("b", [2, 3]))
  assert find(tags, fn(key, _) { key == "d" }) == None
}

// Transforming

/// Returns the keys, with all their values, for which `keep` returns
/// `True`. `keep` is called once per key, in key order, and `compare` is
/// not called: O(n).
pub fn filter<K: Compare, V>(
  m: SortedMultimap<K, V>,
  keep: fn(K, List<V>) -> Bool,
) -> SortedMultimap<K, V> {
  let kept = sorted_map::filter(m.entries, keep)
  let total = sorted_map::fold_entries(kept, 0, fn(sum, _, values) { sum + list::length(values) })
  SortedMultimap { entries: kept, total }
}

test "filter keeps whole keys" {
  let tags = from_list([("a", 1), ("b", 2), ("b", 3)])
  let repeated = filter(tags, fn(_, values) { list::length(values) > 1 })
  assert to_list(repeated) == [("b", [2, 3])]
}

// Text

/// `sorted_multimap::from_list([…])` with one pair per value, in the order
/// of `to_pairs`, each written with `show` (D-344, D-355). It makes
/// `SortedMultimap<K, V>` satisfy `Show` when `K` and `V` do (§8.8, D-064).
pub fn show<K: Compare + Show, V: Show>(m: SortedMultimap<K, V>) -> String {
  let items = to_pairs(m)
  "sorted_multimap::from_list({items})"
}

test "a sorted multimap shows one pair per value" {
  let tags = from_list([("b", 3), ("a", 1), ("a", 2)])
  assert show(tags) == "sorted_multimap::from_list([(a, 1), (a, 2), (b, 3)])"
  assert "{tags}" == "sorted_multimap::from_list([(a, 1), (a, 2), (b, 3)])"
}

// The multimap's own checks

test "count follows inserts, removes and filters" {
  let marks = list::fold(list::range(0, 300), new(), fn(m, n) { insert(m, n % 7, n) })
  assert count(marks) == 300
  assert size(marks) == 7
  assert count(marks) == list::length(to_pairs(marks))
  let fewer = remove(marks, 3)
  assert count(fewer) == 300 - list::length(get(marks, 3))
  let odd = filter(marks, fn(key, _) { key % 2 == 1 })
  assert count(odd) == list::length(to_pairs(odd))
  assert from_list(to_pairs(marks)) == marks
  assert get(marks, 0) == list::filter(list::range(0, 300), fn(n) { n % 7 == 0 })
}
