//! Random numbers from the host's random source and from seeded
//! generators (D-226, D-653 to D-656).
//!
//! The module keeps no state of its own (D-653). A `Generator` is
//! SplitMix64 over a `U64` of state that the value itself holds, and every
//! draw from one is defined bit for bit, so a seed gives the same numbers
//! on every run and every target (D-232, D-655). The one kernel is the
//! private `host_bits`, which returns 64 bits from the host's random
//! source; everything else is written in Cheby over it and over `U64`
//! arithmetic (D-656). The seeded functions therefore run in constants,
//! and a constant that reaches a host function is E0077 (D-090, D-537).
//! The kernel also declares its JS binding, written with the JS back end
//! (D-661). `split`, `next_bool`, `choose` and `shuffle` are fixed bit for
//! bit as well (D-1096).

import std::float
import std::int
import std::list
import std::u64

// Types

/// A seeded random-number generator: SplitMix64 over 64 bits of state
/// (D-655). It is opaque and plain data, so two generators are `==`
/// exactly when they will draw the same numbers, and its debug text is
/// the record's.
pub type Generator {
  state: U64,
}

/// What SplitMix64 adds to the state at each step (D-655).
const increment: U64 = 0x9E37_79B9_7F4A_7C15

/// The multiplier of SplitMix64's first mixing step (D-655).
const first_multiplier: U64 = 0xBF58_476D_1CE4_E5B9

/// The multiplier of SplitMix64's second mixing step (D-655).
const second_multiplier: U64 = 0x94D0_49BB_1331_11EB

/// 2⁵³, the number of fractions `next_fraction` can return (D-655).
const fractions: Float = 9_007_199_254_740_992.0

/// What D-1048 adds to a state once per spawn to derive a new stream, and
/// what `split` adds once (D-1096).
const stream_increment: U64 = 0xD1B5_4A32_D192_ED03

/// The lowest output whose highest bit is 1, 2⁶³ (D-1096).
const highest_bit: U64 = 0x8000_0000_0000_0000

// The host source

/// Returns 64 bits from the host's random source: the operating system's
/// on native, `crypto.getRandomValues` on JS (D-656). No promise of
/// cryptographic strength is made.
@external(native, "cheby_random_host_bits")
@external(js, "./random.mjs", "host_bits")
fn host_bits() -> U64

/// Returns an integer from `low` to `high`, both included, drawn from the
/// host's random source with every integer in that range equally likely.
/// When `high` is less than `low`, it draws from `high` to `low` (D-297,
/// D-654). It is `next_int_between(from_host(), low, high)` without the
/// generator. On JS it panics when the drawn integer is outside
/// ±(2⁵³−1), which needs a bound outside that range (D-037).
pub fn int_between(low: Int, high: Int) -> Int {
  let (drawn, _) = next_int_between(from_host(), low, high)
  drawn
}

test "int_between stays within its bounds" {
  let roll = int_between(1, 6)
  assert roll >= 1 && roll <= 6
  assert int_between(0, 0) == 0
  let reversed = int_between(10, 5)
  assert reversed >= 5 && reversed <= 10
}

/// Returns a `Float` from `0.0` up to but not including `1.0`, drawn from
/// the host's random source: one of the 2⁵³ values `k / 2⁵³`, each equally
/// likely. It is `next_fraction(from_host())` without the generator
/// (D-655).
pub fn fraction() -> Float {
  let (drawn, _) = next_fraction(from_host())
  drawn
}

test "fraction is at least zero and below one" {
  let x = fraction()
  assert x >= 0.0 && x < 1.0
}

/// Returns a generator whose state is 64 bits from the host's random
/// source (D-656).
pub fn from_host() -> Generator {
  Generator { state: host_bits() }
}

// Seeded generators

/// Returns the generator whose state is the 64 bits of `seed` in two's
/// complement (D-655). Every `Int` is a valid seed, and different seeds
/// give different generators.
pub fn from_seed(seed: Int) -> Generator {
  Generator { state: bits_of(seed) }
}

test "a seed always gives the same numbers" {
  let (first, _) = next_int_between(from_seed(42), 1, 6)
  let (again, _) = next_int_between(from_seed(42), 1, 6)
  assert first == again
  assert from_seed(42) == from_seed(42)
  assert from_seed(42) != from_seed(43)
}

/// Returns a new generator and `generator` advanced by one step, in that
/// order (D-1096). The new generator's state is the one D-1048 gives the
/// first fiber spawned from `generator`'s state, and the advanced one is
/// the generator a step leaves, so the two draw different numbers and
/// neither repeats what `generator` would have drawn first.
pub fn split(generator: Generator) -> (Generator, Generator) {
  let (_, advanced) = step(generator)
  (derived(generator, 1), advanced)
}

test "split gives a new generator and the advanced one" {
  let (child, advanced) = split(from_seed(42))
  assert "{child:?}" == "Generator \{ state: 814261035509592648 }"
  assert "{advanced:?}" == "Generator \{ state: 11400714819323198527 }"
  let (_, after_one) = next_fraction(from_seed(42))
  assert advanced == after_one
  assert split(from_seed(42)) == (child, advanced)
}

test "split derives generators that draw apart" {
  fn rolls(generator, count, drawn) {
    case count {
      0 => drawn
      _ => {
        let (n, next) = next_int_between(generator, 1, 6)
        rolls(next, count - 1, [..drawn, n])
      }
    }
  }
  let (child, advanced) = split(from_seed(42))
  assert rolls(child, 5, []) == [5, 6, 3, 3, 1]
  assert rolls(advanced, 5, []) == [2, 1, 1, 5, 1]
  let (grandchild, _) = split(child)
  assert "{grandchild:?}" == "Generator \{ state: 735673624672101622 }"
  let (from_zero, _) = split(from_seed(0))
  assert "{from_zero:?}" == "Generator \{ state: 9370218965779684112 }"
}

/// The 64 bits of `n` in two's complement.
fn bits_of(n: Int) -> U64 {
  u64::wrapping_from_int(n)
}

/// The `Int` whose two's-complement bits are `bits`, the inverse of
/// `bits_of`. On JS it panics outside ±(2⁵³−1) (D-037).
fn int_of(bits: U64) -> Int {
  int::wrapping_from_u64(bits)
}

@target(native)
test "seeds are the two's-complement bits of every Int" {
  assert bits_of(-1) == u64::max_value
  assert int_of(u64::max_value) == -1
  assert int_of(bits_of(int::min_value)) == int::min_value
  assert int_of(bits_of(int::max_value)) == int::max_value
  assert int_of(bits_of(0)) == 0
}

/// SplitMix64's output function, the mixing of a step (D-655).
fn mix(z: U64) -> U64 {
  let mixed = u64::wrapping_mul(z ^ (z >> 30), first_multiplier)
  let remixed = u64::wrapping_mul(mixed ^ (mixed >> 27), second_multiplier)
  remixed ^ (remixed >> 31)
}

/// One step of SplitMix64: its output and the generator after it
/// (D-655).
fn step(generator: Generator) -> (U64, Generator) {
  let state = u64::wrapping_add(generator.state, increment)
  (mix(state), Generator { state: state })
}

/// The generator that D-1048 derives from `generator` for the `n`th spawn
/// since its last draw: the state `s + n × 0xD1B54A32D192ED03` modulo
/// 2⁶⁴, put through `mix`. `split` takes the first (D-1096), and M4's
/// seeded streams take each spawn's.
fn derived(generator: Generator, n: U64) -> Generator {
  let offset = u64::wrapping_mul(n, stream_increment)
  Generator { state: mix(u64::wrapping_add(generator.state, offset)) }
}

/// Steps `generator` until an output is at least `threshold`, and returns
/// that output and the generator after it (D-655).
fn step_until(generator: Generator, threshold: U64) -> (U64, Generator) {
  let (output, next) = step(generator)
  case output >= threshold {
    True => (output, next)
    False => step_until(next, threshold)
  }
}

/// Returns an integer from `low` to `high`, both included, and the
/// generator that comes after it, with every integer in the range equally
/// likely. When `high` is less than `low`, it draws from `high` to `low`
/// (D-297, D-654). The draw is SplitMix64's, mapped to the range by
/// rejecting outputs below `(2⁶⁴ − span) % span` and taking
/// `low + x % span`, where `span` is the number of integers in the range
/// modulo 2⁶⁴; a span of all 2⁶⁴ integers takes one output as it is
/// (D-655). On JS it panics when the drawn integer is outside ±(2⁵³−1),
/// which needs a bound outside that range (D-037).
pub fn next_int_between(generator: Generator, low: Int, high: Int) -> (Int, Generator) {
  let start = bits_of(int::min(low, high))
  let span = u64::wrapping_add(u64::wrapping_sub(bits_of(int::max(low, high)), start), 1)
  case span {
    0 => {
      let (output, next) = step(generator)
      (int_of(output), next)
    }
    _ => {
      let (output, next) = step_until(generator, u64::wrapping_neg(span) % span)
      // The sum wraps exactly as two's-complement `Int` addition would,
      // and the result lies between the bounds, so it never overflows.
      (int_of(u64::wrapping_add(start, output % span)), next)
    }
  }
}

test "next_int_between rolls a die from a seed" {
  fn roll(generator, count, rolls) {
    case count {
      0 => rolls
      _ => {
        let (n, next) = next_int_between(generator, 1, 6)
        roll(next, count - 1, [..rolls, n])
      }
    }
  }
  assert roll(from_seed(42), 10, []) == [2, 2, 1, 1, 5, 1, 2, 3, 2, 3]
  assert roll(from_seed(2026), 5, []) == [2, 6, 3, 1, 4]
}

test "next_int_between treats its bounds alike in either order" {
  let generator = from_seed(7)
  assert next_int_between(generator, 6, 1) == next_int_between(generator, 1, 6)
  let (zero, _) = next_int_between(generator, 0, 0)
  assert zero == 0
}

@target(native)
test "next_int_between covers the widest ranges" {
  let generator = from_seed(1)
  // All 2⁶⁴ integers: one output, read as an `Int`.
  let (output, after_one) = step(generator)
  assert next_int_between(generator, int::min_value, int::max_value) == (int_of(output), after_one)
  let (wide, _) = next_int_between(generator, int::min_value, int::max_value - 1)
  assert wide < int::max_value
  let (top, _) = next_int_between(generator, int::max_value, int::max_value)
  assert top == int::max_value
}

/// Returns a `Float` from `0.0` up to but not including `1.0`, and the
/// generator that comes after it. It takes one step and returns the
/// output's top 53 bits divided by 2⁵³, which is exact (D-655).
pub fn next_fraction(generator: Generator) -> (Float, Generator) {
  let (output, next) = step(generator)
  let assert Ok(top) = int::from_u64(output >> 11)
  (float::from_int(top) / fractions, next)
}

test "next_fraction draws from a seed" {
  let (a, after) = next_fraction(from_seed(42))
  let (b, _) = next_fraction(after)
  assert a == 0.7415648787718233
  assert b == 0.1599103928769201
}

/// Returns `True` or `False`, each equally likely, and the generator that
/// comes after it. It takes one step and returns `True` when the output's
/// highest bit is 1 (D-1096).
pub fn next_bool(generator: Generator) -> (Bool, Generator) {
  let (output, next) = step(generator)
  (output >= highest_bit, next)
}

test "next_bool flips coins from a seed" {
  fn flips(generator, count, drawn) {
    case count {
      0 => drawn
      _ => {
        let (b, next) = next_bool(generator)
        flips(next, count - 1, [..drawn, b])
      }
    }
  }
  assert flips(from_seed(42), 10, []) == [
    True,
    False,
    False,
    False,
    False,
    True,
    False,
    True,
    False,
    True,
  ]
  assert flips(from_seed(7), 4, []) == [False, False, True, True]
}

/// Returns an element of `xs`, each position equally likely, and the
/// generator that comes after it: the element at `next_int_between(generator,
/// 0, length - 1)`. An empty list gives `(None, generator)` and draws
/// nothing (D-1096).
pub fn choose<T>(generator: Generator, xs: List<T>) -> (Option<T>, Generator) {
  case xs {
    [] => (None, generator)
    _ => {
      let (index, next) = next_int_between(generator, 0, list::length(xs) - 1)
      (list::get(xs, index), next)
    }
  }
}

test "choose picks an element from a seed" {
  fn picks(generator, count, drawn) {
    case count {
      0 => drawn
      _ => {
        let (pick, next) = choose(generator, ["a", "b", "c"])
        picks(next, count - 1, [..drawn, pick])
      }
    }
  }
  assert picks(from_seed(42), 6, []) == [
    Some("b"),
    Some("b"),
    Some("a"),
    Some("a"),
    Some("b"),
    Some("a"),
  ]
  assert choose::<Int>(from_seed(7), []) == (None, from_seed(7))
}

/// Returns the elements of `xs` in an order drawn with every order equally
/// likely, and the generator that comes after it. It is Fisher–Yates: for
/// `i` from `length - 1` down to 1, it draws `j` with
/// `next_int_between(generator, 0, i)` and swaps the elements at `i` and
/// `j`. A list of fewer than two elements draws nothing (D-1096).
pub fn shuffle<T>(generator: Generator, xs: List<T>) -> (List<T>, Generator) {
  shuffle_down(generator, xs, list::length(xs) - 1)
}

/// The Fisher–Yates steps of `shuffle` from position `i` down to 1.
fn shuffle_down<T>(generator: Generator, xs: List<T>, i: Int) -> (List<T>, Generator) {
  case i < 1 {
    True => (xs, generator)
    False => {
      let (j, next) = next_int_between(generator, 0, i)
      shuffle_down(next, swapped(xs, i, j), i - 1)
    }
  }
}

/// `xs` with the elements at `i` and `j` swapped. Both are positions of
/// `xs`.
fn swapped<T>(xs: List<T>, i: Int, j: Int) -> List<T> {
  let assert Some(at_i) = list::get(xs, i)
  let assert Some(at_j) = list::get(xs, j)
  xs
  |> list::set(_, i, at_j)
  |> list::set(_, j, at_i)
}

test "shuffle reorders a list from a seed" {
  let (shuffled, _) = shuffle(from_seed(42), list::range(1, 11))
  assert shuffled == [1, 10, 6, 9, 7, 5, 8, 3, 2, 4]
  let (letters, _) = shuffle(from_seed(2026), ["a", "b", "c", "d", "e"])
  assert letters == ["d", "a", "c", "e", "b"]
  assert shuffle(from_seed(42), [1]) == ([1], from_seed(42))
  assert shuffle::<Int>(from_seed(42), []) == ([], from_seed(42))
}
