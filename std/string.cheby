//! The built-in `String`, immutable Unicode text: measuring, searching,
//! splitting, building and changing text, and conversions.
//!
//! Every length, position and count is in code points (D-302).
//! `String` itself is a builtin item whose home module is this one (D-447).

import std::bytes

// Measuring

/// Returns the number of code points in `text` (D-302).
@external(native, "cheby_string_length")
@external(js, "./string.mjs", "length")
pub fn length(text: String) -> Int

test "length counts code points" {
  assert length("") == 0
  assert length("café") == 4
  assert length("e\u{301}") == 2
  assert length("🇳🇱") == 2
}

/// Tells whether `text` is `""`.
pub fn is_empty(text: String) -> Bool {
  text == ""
}

test "is_empty is true only for the empty string" {
  assert is_empty("")
  assert !is_empty(" ")
}

/// Returns the number of extended grapheme clusters in `text` (D-302, D-310).
@external(native, "cheby_string_grapheme_length")
@external(js, "./string.mjs", "grapheme_length")
pub fn grapheme_length(text: String) -> Int

test "grapheme_length counts what a reader sees" {
  assert grapheme_length("café") == 4
  assert grapheme_length("e\u{301}") == 1
  assert grapheme_length("🇳🇱") == 1
}

// Comparing and searching

/// Orders strings by their code points (D-136). It makes `String` satisfy `Compare`.
@external(native, "cheby_string_compare")
@external(js, "./string.mjs", "compare")
pub fn compare(a: String, b: String) -> Order

/// Tells whether `text` begins with `prefix`.
@external(native, "cheby_string_starts_with")
@external(js, "./string.mjs", "starts_with")
pub fn starts_with(text: String, prefix: String) -> Bool

test "starts_with checks the beginning" {
  assert starts_with("https://example.com", "https://")
  assert !starts_with("http", "https")
  assert starts_with("text", "")
}

/// Tells whether `text` ends with `suffix`.
@external(native, "cheby_string_ends_with")
@external(js, "./string.mjs", "ends_with")
pub fn ends_with(text: String, suffix: String) -> Bool

test "ends_with checks the end" {
  assert ends_with("report.csv", ".csv")
  assert !ends_with("report.csv", ".json")
  assert ends_with("text", "")
}

/// Tells whether `part` occurs anywhere in `text`.
@external(native, "cheby_string_contains")
@external(js, "./string.mjs", "contains")
pub fn contains(text: String, part: String) -> Bool

test "contains finds a part anywhere" {
  assert contains("hello world", "o w")
  assert !contains("hello", "world")
  assert contains("", "")
}

// Splitting

/// Splits `text` at every `separator`, and into code points when it is empty (D-315).
@external(native, "cheby_string_split")
@external(js, "./string.mjs", "split")
pub fn split(text: String, separator: String) -> List<String>

test "split keeps empty parts" {
  assert split("a,b,,c", ",") == ["a", "b", "", "c"]
  assert split("a,b,", ",") == ["a", "b", ""]
  assert split("", ",") == [""]
  assert split("abc", "-") == ["abc"]
}

test "split on an empty separator gives code points" {
  assert split("abc", "") == ["a", "b", "c"]
  assert split("", "") == []
}

/// Splits `text` at the first occurrence of `separator`, or gives `None` (D-315).
@external(native, "cheby_string_split_once")
@external(js, "./string.mjs", "split_once")
pub fn split_once(text: String, separator: String) -> Option<(String, String)>

test "split_once splits at the first separator" {
  assert split_once("key=value=1", "=") == Some(("key", "value=1"))
  assert split_once("key", "=") == None
  assert split_once("abc", "") == Some(("a", "bc"))
}

/// Splits `text` into lines at each `\n`, removing one `\r` right before
/// each `\n`, with no part after a final `\n` (D-1092). No other code point
/// ends a line, as for `io::read_line` (D-305).
pub fn lines(text: String) -> List<String> {
  // Every part but the last was followed by `\n`, so only those lose a
  // `\r`. The last part is `""` exactly when `text` ends with `\n` or is
  // empty, and then it is no line.
  fn ended(parts, done) {
    case parts {
      [] => done
      [""] => done
      [final] => [..done, final]
      [part, ..rest] => ended(rest, [..done, remove_suffix(part, "\r")])
    }
  }
  ended(split(text, "\n"), [])
}

test "lines splits at line feeds and drops the carriage return before each" {
  assert lines("a\nb\r\nc") == ["a", "b", "c"]
  assert lines("a\n\nb\n") == ["a", "", "b"]
  assert lines("a\rb") == ["a\rb"]
  assert lines("") == []
  assert lines("\n") == [""]
}

test "lines ends a line only at a line feed" {
  assert lines("a\r\n") == ["a"]
  assert lines("a\r") == ["a\r"]
  assert lines("a\r\r\nb") == ["a\r", "b"]
  assert lines("a\u{85}b\u{2028}c\u{2029}d") == ["a\u{85}b\u{2028}c\u{2029}d"]
  assert lines("\r\n\r\n") == ["", ""]
}

/// Splits `text` at every run of Unicode `White_Space`, the whitespace
/// `trim` removes, with no empty parts (D-310, D-1092).
@external(native, "cheby_string_words")
@external(js, "./string.mjs", "words")
pub fn words(text: String) -> List<String>

test "words splits at runs of White_Space" {
  assert words("  one\ttwo\u{3000}three \r\n") == ["one", "two", "three"]
  assert words("a\u{85}b") == ["a", "b"]
  assert words("\u{FEFF}x") == ["\u{FEFF}x"]
  assert words(" \t ") == []
}

test "words keeps text that is not White_Space together" {
  assert words("") == []
  assert words("solo") == ["solo"]
  assert words("a\u{200B}b\u{A0}c") == ["a\u{200B}b", "c"]
  assert words("x\u{2028}y\u{FEFF}") == ["x", "y\u{FEFF}"]
}

/// Splits `text` into its code points, each as a one-code-point string (D-302).
@external(native, "cheby_string_to_code_points")
@external(js, "./string.mjs", "to_code_points")
pub fn to_code_points(text: String) -> List<String>

test "to_code_points splits into scalar values" {
  assert to_code_points("abc") == ["a", "b", "c"]
  assert to_code_points("e\u{301}") == ["e", "\u{301}"]
  assert to_code_points("") == []
}

/// Splits `text` into its extended grapheme clusters (D-302, D-310).
@external(native, "cheby_string_to_graphemes")
@external(js, "./string.mjs", "to_graphemes")
pub fn to_graphemes(text: String) -> List<String>

test "to_graphemes keeps clusters together" {
  assert to_graphemes("e\u{301}a") == ["e\u{301}", "a"]
  assert to_graphemes("🇳🇱!") == ["🇳🇱", "!"]
  assert to_graphemes("") == []
}

// Building

/// Returns `a` followed by `b`. It makes `String` satisfy `Add`, so `+` concatenates.
@external(native, "cheby_string_add")
@external(js, "./string.mjs", "add")
pub fn add(a: String, b: String) -> String

test "add concatenates" {
  let given = "Ada"
  assert add("con", "cat") == "concat"
  assert given + " " + "Lovelace" == "Ada Lovelace"
}

/// Returns `out` followed by `text` between `"`, escaped as JSON text:
/// `"` and `\` get a backslash, the control characters below U+0020 become
/// `\b`, `\f`, `\n`, `\r`, `\t` or `\u00` and two lower-case hex digits,
/// and every other code point is copied (D-326, D-398). `std::json` writes
/// its strings with it, and it extends a unique `out` as `add` does (D-903).
@external(native, "cheby_string_add_json_quoted")
@external(js, "./string.mjs", "add_json_quoted")
fn add_json_quoted(out: String, text: String) -> String

test "add_json_quoted adds the text quoted and escaped as JSON" {
  assert add_json_quoted("", "") == r#""""#
  assert add_json_quoted("[", "plain é ☃") == r#"["plain é ☃""#
  assert add_json_quoted("", "a\"b\\c/") == r#""a\"b\\c/""#
  assert add_json_quoted("", "\u{8}\u{C}\n\r\t") == r#""\b\f\n\r\t""#
  assert add_json_quoted("x", "\u{0}\u{1F}") == r#"x"\u0000\u001f""#
  let kept = "\u{7F}\u{80}\u{9F}\u{2028}\u{2029}\u{10FFFF}"
  assert add_json_quoted("", kept) == "\"" + kept + "\""
  let text = "x\"y"
  assert add_json_quoted(text, text) == r#"x"y"x\"y""#
}

/// Returns the elements of `parts` in order, with `separator` between each two.
@external(native, "cheby_string_join")
@external(js, "./string.mjs", "join")
pub fn join(parts: List<String>, separator: String) -> String

test "join puts the separator between parts" {
  assert join(["a", "b", "c"], ", ") == "a, b, c"
  assert join(["only"], ", ") == "only"
  assert join([], ", ") == ""
  assert ["x", "y"]
    |> join(_, "") == "xy"
}

/// Returns `count` copies of `text`, one after another.
@external(native, "cheby_string_repeat")
@external(js, "./string.mjs", "repeat")
@std_clamped(count)
pub fn repeat(text: String, count: Int) -> String

test "repeat copies the text" {
  let negative = -2
  assert repeat("ab", 3) == "ababab"
  assert repeat("ab", 0) == ""
  assert repeat("ab", negative) == ""
}

/// Returns `text` with copies of `pad` in front, so that it is `width` code points long.
@external(native, "cheby_string_pad_start")
@external(js, "./string.mjs", "pad_start")
@std_clamped(width)
pub fn pad_start(text: String, width: Int, pad: String) -> String

test "pad_start pads on the left" {
  let negative = -3
  assert pad_start("7", 3, "0") == "007"
  assert pad_start("121", 6, "ab") == "aba121"
  assert pad_start("", 3, "-") == "---"
  assert pad_start("é", 3, " ") == "  é"
  assert pad_start("long", 2, " ") == "long"
  assert pad_start("text", negative, " ") == "text"
}

/// Returns `text` with copies of `pad` after it, so that it is `width` code points long.
@external(native, "cheby_string_pad_end")
@external(js, "./string.mjs", "pad_end")
@std_clamped(width)
pub fn pad_end(text: String, width: Int, pad: String) -> String

test "pad_end pads on the right" {
  assert pad_end("200", 8, " ") == "200     "
  assert pad_end("121", 6, "ab") == "121aba"
  assert pad_end("long", 2, " ") == "long"
}

// Changing

/// Removes Unicode `White_Space` from both ends of `text` (D-310).
@external(native, "cheby_string_trim")
@external(js, "./string.mjs", "trim")
pub fn trim(text: String) -> String

test "trim removes whitespace at both ends" {
  assert trim("  hi there \n") == "hi there"
  assert trim("\t\r\n") == ""
  assert trim("\u{3000}x") == "x"
}

/// Removes Unicode `White_Space` from the start of `text` (D-373).
@external(native, "cheby_string_trim_start")
@external(js, "./string.mjs", "trim_start")
pub fn trim_start(text: String) -> String

test "trim_start removes whitespace at the start" {
  assert trim_start("  hi ") == "hi "
  assert trim_start("\t\nx") == "x"
}

/// Removes Unicode `White_Space` from the end of `text` (D-373).
@external(native, "cheby_string_trim_end")
@external(js, "./string.mjs", "trim_end")
pub fn trim_end(text: String) -> String

test "trim_end removes whitespace at the end" {
  assert trim_end(" hi  ") == " hi"
  assert trim_end("line\r\n") == "line"
}

/// Removes one `prefix` from the start of `text`, if it is there (D-373).
@external(native, "cheby_string_remove_prefix")
@external(js, "./string.mjs", "remove_prefix")
pub fn remove_prefix(text: String, prefix: String) -> String

test "remove_prefix removes one occurrence" {
  assert remove_prefix("https://example.com", "https://") == "example.com"
  assert remove_prefix("0042", "0") == "042"
  assert remove_prefix("text", "x") == "text"
}

/// Removes one `suffix` from the end of `text`, if it is there (D-373).
@external(native, "cheby_string_remove_suffix")
@external(js, "./string.mjs", "remove_suffix")
pub fn remove_suffix(text: String, suffix: String) -> String

test "remove_suffix removes one occurrence" {
  assert remove_suffix("https://example.com/", "/") == "https://example.com"
  assert remove_suffix("a//", "/") == "a/"
  assert remove_suffix("text", "") == "text"
}

/// Replaces every occurrence of `pattern` in `text` with `replacement` (D-315, D-374).
pub fn replace(text: String, pattern: String, replacement: String) -> String {
  join(split(text, pattern), replacement)
}

test "replace changes every occurrence" {
  assert replace("a-b-c", "-", "+") == "a+b+c"
  assert replace("aaa", "aa", "b") == "ba"
  assert replace("abc", "x", "y") == "abc"
  assert replace("abc", "", "-") == "a-b-c"
}

/// Converts `text` to lower case with Unicode's full case mapping (D-310).
@external(native, "cheby_string_lowercase")
@external(js, "./string.mjs", "lowercase")
pub fn lowercase(text: String) -> String

test "lowercase applies Unicode case mapping" {
  assert lowercase("Hello, World") == "hello, world"
  assert lowercase("ÉCOLE") == "école"
  assert lowercase("I") == "i"
}

/// Converts `text` to upper case with Unicode's full case mapping (D-310).
@external(native, "cheby_string_uppercase")
@external(js, "./string.mjs", "uppercase")
pub fn uppercase(text: String) -> String

test "uppercase applies Unicode case mapping" {
  assert uppercase("a1b2") == "A1B2"
  assert uppercase("straße") == "STRASSE"
  assert uppercase("i") == "I"
}

/// Returns the code points of `text` in reverse order (D-302).
@external(native, "cheby_string_reverse")
@external(js, "./string.mjs", "reverse")
pub fn reverse(text: String) -> String

test "reverse reverses code points" {
  assert reverse("stressed") == "desserts"
  assert reverse("e\u{301}x") == "x\u{301}e"
  assert reverse("") == ""
}

/// Returns the code points of `text` from `start` up to but not including `end` (D-319).
@external(native, "cheby_string_slice")
@external(js, "./string.mjs", "slice")
@std_clamped(start, end)
pub fn slice(text: String, start: Int, end: Int) -> String

test "slice takes code points by position" {
  let negative = -5
  assert slice("héllo", 1, 3) == "él"
  assert slice("abc", 1, 10) == "bc"
  assert slice("abc", negative, 1) == "a"
  assert slice("abc", 2, 1) == ""
}

// Conversions

/// Decodes `data` as UTF-8, or gives `Err(Nil)` when it is not valid UTF-8 (D-366).
@external(native, "cheby_string_from_bytes")
@external(js, "./string.mjs", "from_bytes")
pub fn from_bytes(data: bytes::Bytes) -> Result<String, Nil>

test "from_bytes decodes UTF-8" {
  assert from_bytes(bytes::from_list([0x63, 0x61, 0x66, 0xC3, 0xA9])) == Ok("café")
  assert from_bytes(bytes::from_string("round trip")) == Ok("round trip")
  assert from_bytes(bytes::new()) == Ok("")
}

test "from_bytes rejects invalid UTF-8" {
  assert from_bytes(bytes::from_list([0xFF])) == Err(Nil)
  assert from_bytes(bytes::from_list([0xC3])) == Err(Nil)
  assert from_bytes(bytes::from_list([0xED, 0xA0, 0x80])) == Err(Nil)
}

/// Decodes `data` as UTF-8, replacing each invalid sequence with U+FFFD by
/// the maximal-subpart practice of `from_byte_range`, and keeping a leading
/// U+FEFF (D-366, D-905, D-1093).
pub fn from_bytes_lossy(data: bytes::Bytes) -> String {
  from_byte_range(data, 0, bytes::length(data))
}

test "from_bytes_lossy replaces each invalid sequence" {
  assert from_bytes_lossy(bytes::from_list([0x61, 0xFF, 0x62])) == "a\u{FFFD}b"
  assert from_bytes_lossy(bytes::from_list([0xE2, 0x82])) == "\u{FFFD}"
  assert from_bytes_lossy(bytes::from_string("café")) == "café"
}

test "from_bytes_lossy replaces maximal subparts and keeps a byte-order mark" {
  let surrogate = bytes::from_list([0xED, 0xA0, 0x80])
  assert from_bytes_lossy(surrogate) == "\u{FFFD}\u{FFFD}\u{FFFD}"
  let cut = bytes::from_list([0xF0, 0x9F, 0x98, 0x41])
  assert from_bytes_lossy(cut) == "\u{FFFD}A"
  assert from_bytes_lossy(bytes::from_list([0xEF, 0xBB, 0xBF, 0x78])) == "\u{FEFF}x"
  assert from_bytes_lossy(bytes::new()) == ""
}

/// Returns the bytes of `data` from `start` up to but not including `end` as
/// text, with both clamped as `bytes::slice` clamps them (D-298). Each
/// invalid UTF-8 sequence becomes U+FFFD, and a byte-order mark at the start
/// is kept as U+FEFF, as `from_bytes` keeps it (D-366). `std::json` reads the
/// text of its strings and numbers with it (D-905).
@external(native, "cheby_string_from_byte_range")
@external(js, "./string.mjs", "from_byte_range")
@std_clamped(start, end)
fn from_byte_range(data: bytes::Bytes, start: Int, end: Int) -> String

test "from_byte_range decodes a clamped range of bytes" {
  let data = bytes::from_string("abcdefgé")
  let negative = -1
  assert from_byte_range(data, 0, 2) == "ab"
  assert from_byte_range(data, negative, 2) == "ab"
  assert from_byte_range(data, 5, 9) == "fgé"
  assert from_byte_range(data, 6, 99) == "gé"
  assert from_byte_range(data, 2, 2) == ""
  assert from_byte_range(data, 3, 1) == ""
  assert from_byte_range(bytes::new(), 0, 1) == ""
}

test "from_byte_range replaces invalid UTF-8" {
  let data = bytes::from_string("abcdefgé")
  assert from_byte_range(data, 7, 8) == "\u{FFFD}"
  assert from_byte_range(data, 8, 9) == "\u{FFFD}"
  assert from_byte_range(bytes::from_list([0x61, 0xFF, 0x62]), 0, 3) == "a\u{FFFD}b"
  assert from_byte_range(bytes::from_list([0xED, 0xA0, 0x80]), 0, 3) == "\u{FFFD}\u{FFFD}\u{FFFD}"
}

test "from_byte_range keeps a leading byte-order mark" {
  assert from_byte_range(bytes::from_list([0xEF, 0xBB, 0xBF, 0x78]), 0, 4) == "\u{FEFF}x"
}

/// Returns the Unicode scalar value of each code point of `text`, in order.
@external(native, "cheby_string_to_code_point_values")
@external(js, "./string.mjs", "to_code_point_values")
pub fn to_code_point_values(text: String) -> List<Int>

test "to_code_point_values gives scalar values" {
  assert to_code_point_values("aé") == [97, 233]
  assert to_code_point_values("") == []
}

/// Returns the string of the code points in `values`, or `Err(Nil)` for a non-scalar value.
@external(native, "cheby_string_from_code_point_values")
@external(js, "./string.mjs", "from_code_point_values")
pub fn from_code_point_values(values: List<Int>) -> Result<String, Nil>

test "from_code_point_values builds text" {
  assert from_code_point_values([104, 105]) == Ok("hi")
  assert from_code_point_values([0x1F600]) == Ok("\u{1F600}")
  assert from_code_point_values([0xD800]) == Err(Nil)
  assert from_code_point_values([0x110000]) == Err(Nil)
}

/// Returns `text` unchanged. It makes `String` satisfy `Show`.
pub fn show(text: String) -> String {
  text
}

test "a string shows as itself" {
  let name = "Ada \"the first\""
  assert show("plain") == "plain"
  assert "{name}" == "Ada \"the first\""
}

// Tests of `std::bytes` that need this module.

test "from_string encodes UTF-8" {
  assert bytes::to_list(bytes::from_string("hi")) == [0x68, 0x69]
  assert bytes::length(bytes::from_string("café")) == 5
  assert from_bytes(bytes::from_string("café")) == Ok("café")
  assert bytes::from_string("") == bytes::new()
}

// Puzzle helpers. They sit at the end of the file, so no std location that
// a golden pins moves (D-1603).

/// Returns the first code point of `text` as a one-code-point string, or
/// `None` for `""` (D-302, D-1649).
pub fn first(text: String) -> Option<String> {
  case slice(text, 0, 1) {
    "" => None
    head => Some(head)
  }
}

test "first reads the first code point" {
  assert first("L68") == Some("L")
  assert first("éa") == Some("é")
  assert first("x") == last("x")
  assert first("") == None
}

/// Returns the last code point of `text` as a one-code-point string, or
/// `None` for `""` (D-302, D-1649).
pub fn last(text: String) -> Option<String> {
  let size = length(text)
  case slice(text, size - 1, size) {
    "" => None
    tail => Some(tail)
  }
}

test "last reads the last code point" {
  assert last("L68") == Some("8")
  assert last("a😀") == Some("😀")
  assert last("e\u{301}") == Some("\u{301}")
  assert last("") == None
}

/// Returns `text` without its first `count` code points (D-302, D-1649).
@std_clamped(count)
pub fn drop_start(text: String, count: Int) -> String {
  slice(text, count, length(text))
}

test "drop_start removes code points from the front" {
  let negative = -2
  let far = 0 - 9_007_199_254_740_991
  assert drop_start("L68", 1) == "68"
  assert drop_start("héllo", 2) == "llo"
  assert drop_start("abc", 0) == "abc"
  assert drop_start("abc", 5) == ""
  assert drop_start("abc", negative) == "abc"
  assert drop_start("abc", far) == "abc"
}

/// Returns `text` without its last `count` code points (D-302, D-1649).
@std_clamped(count)
pub fn drop_end(text: String, count: Int) -> String {
  case count > 0 {
    True => slice(text, 0, length(text) - count)
    False => text
  }
}

test "drop_end removes code points from the back" {
  let negative = -2
  let far = 0 - 9_007_199_254_740_991
  assert drop_end("L68", 2) == "L"
  assert drop_end("héllo", 4) == "h"
  assert drop_end("abc", 0) == "abc"
  assert drop_end("abc", 5) == ""
  assert drop_end("abc", negative) == "abc"
  assert drop_end("abc", far) == "abc"
}
