//! The insertion-ordered map `OrderedMap<K, V>`, a persistent map that
//! keeps its entries in the order their keys were first inserted (D-331,
//! D-337), written in Cheby over `std::map` with no runtime kernel (D-336,
//! D-664).
//!
//! A `Map` holds each key's value together with the keys just before and
//! just after it, so the order is a doubly linked list threaded through
//! the map, and the record names the oldest and the newest key. A new key
//! is linked after the newest one. Inserting a key that is already present
//! leaves its links alone, so it keeps its place; removing a key links its
//! two neighbours to each other, so inserting it again puts it at the end
//! (D-340). Every update is a few map operations and no comparison: keys
//! are hashed and compared by the runtime's built-in routines, and no
//! `compare` of the key type is ever called.

import std::list
import std::map
import std::set
import std::string

/// The place of a key in the order, and its value: `before` and `after`
/// name the keys next to it, `None` at the two ends of the order.
type Entry<K, V> {
  before: Option<K>,
  after: Option<K>,
  value: V,
}

/// A persistent map in insertion order (D-331, D-337, D-340). `index`
/// maps each key to its entry, and `oldest` and `newest` name the two
/// ends of the order, both `None` for an empty map. Following `after`
/// from `oldest` visits every key of `index` once and stops at
/// `newest`, and `before` links the same keys the other way. The links
/// name only keys that are present, so two maps with the same entries in
/// the same order have the same fields, whatever their history. Equality,
/// hashing and debug printing go through `equal`, `hash` and `debug`
/// (D-342, D-343).
@std_hooks(equal, hash, debug)
pub type OrderedMap<K, V> {
  index: map::Map<K, Entry<K, V>>,
  oldest: Option<K>,
  newest: Option<K>,
}

/// Whether two maps hold the same entries in the same order, keys and
/// values compared with `==` (D-343).
fn equal<K, V>(a: OrderedMap<K, V>, b: OrderedMap<K, V>) -> Bool {
  size(a) == size(b) && to_list(a) == to_list(b)
}

/// The entries in order: equal maps give equal lists, and the hash covers
/// the order (D-343, D-584).
fn hash<K, V>(m: OrderedMap<K, V>) -> List<(K, V)> {
  to_list(m)
}

/// `ordered_map::from_list([…])` with the entries in order, each one
/// debug-printed (D-344).
fn debug<K, V>(m: OrderedMap<K, V>) -> String {
  let pairs = to_list(m)
  "ordered_map::from_list({pairs:?})"
}

test "ordered maps compare, hash and print by contents and order" {
  let ab = from_list([("a", 1), ("b", 2)])
  let ba = from_list([("b", 2), ("a", 1)])
  let grown = insert(from_list([("a", 1)]), "b", 2)
  assert ab == grown
  assert ab != ba
  assert set::size(set::from_list([ab, grown, ba])) == 2
  assert "{ba:?}" == "ordered_map::from_list([(\"b\", 2), (\"a\", 1)])"
}

// Building

/// Returns an empty map.
pub fn new<K, V>() -> OrderedMap<K, V> {
  OrderedMap { index: map::new(), oldest: None, newest: None }
}

test "new is empty" {
  let empty = new::<String, Int>()
  assert is_empty(empty)
  assert to_list(empty) == []
}

/// Returns a map with the given pairs, as if each were inserted in turn:
/// the last value of a repeated key wins (D-329), and the key keeps the
/// place of its first occurrence (D-340).
pub fn from_list<K, V>(pairs: List<(K, V)>) -> OrderedMap<K, V> {
  list::fold(pairs, new(), fn(built, (key, value)) { insert(built, key, value) })
}

test "from_list keeps the first position and the last value" {
  let fruit = from_list([("pear", 1), ("apple", 2), ("pear", 3)])
  assert to_list(fruit) == [("pear", 3), ("apple", 2)]
}

// Size

/// Returns the number of keys, O(1).
pub fn size<K, V>(m: OrderedMap<K, V>) -> Int {
  map::size(m.index)
}

test "size counts keys" {
  assert size(from_list([("a", 1), ("b", 2), ("a", 3)])) == 2
  assert size(new::<String, Int>()) == 0
}

/// Tells whether the map has no keys.
pub fn is_empty<K, V>(m: OrderedMap<K, V>) -> Bool {
  map::is_empty(m.index)
}

test "is_empty tells an empty map" {
  assert is_empty(new::<String, Int>())
  assert !is_empty(from_list([("a", 1)]))
}

// Lookup

/// Returns the value stored under `key`.
pub fn get<K, V>(m: OrderedMap<K, V>, key: K) -> Option<V> {
  case map::get(m.index, key) {
    Some(found) => Some(found.value)
    None => None
  }
}

test "get looks a key up" {
  let ages = from_list([("ada", 36), ("alan", 41)])
  assert get(ages, "alan") == Some(41)
  assert get(ages, "grace") == None
}

/// Tells whether `key` is in the map.
pub fn has_key<K, V>(m: OrderedMap<K, V>, key: K) -> Bool {
  map::has_key(m.index, key)
}

test "has_key tells whether a key is present" {
  let ages = from_list([("ada", 36)])
  assert has_key(ages, "ada")
  assert !has_key(ages, "alan")
}

/// The key `end`, one end of the order, with its value.
fn end_entry<K, V>(index: map::Map<K, Entry<K, V>>, end: Option<K>) -> Option<(K, V)> {
  case end {
    Some(key) => case map::get(index, key) {
      Some(found) => Some((key, found.value))
      None => None
    }
    None => None
  }
}

/// Returns the entry that comes first in the map's order, the oldest key
/// still present.
pub fn first<K, V>(m: OrderedMap<K, V>) -> Option<(K, V)> {
  end_entry(m.index, m.oldest)
}

test "first is the oldest key" {
  let queue = from_list([("bob", 2), ("ada", 1), ("cy", 3)])
  assert first(queue) == Some(("bob", 2))
  assert first(remove(queue, "bob")) == Some(("ada", 1))
  assert first(new::<String, Int>()) == None
}

/// Returns the entry that comes last in the map's order, the key inserted
/// most recently.
pub fn last<K, V>(m: OrderedMap<K, V>) -> Option<(K, V)> {
  end_entry(m.index, m.newest)
}

test "last is the newest key" {
  let queue = from_list([("bob", 2), ("ada", 1), ("cy", 3)])
  assert last(queue) == Some(("cy", 3))
  assert last(new::<String, Int>()) == None
}

// Updating

// `insert`, `remove` and `upsert` take the record apart first, so `m` ends
// before its index changes: an index held only by the caller reaches
// `map` unshared and is updated in place (D-716). `insert` and `upsert`
// change the key's entry with one `map::upsert`, which links a new key
// after the newest. The index grows only for a new key, so its size tells
// whether the newest key's entry must also point to the new one.

/// `found`, the entry of a key that a link names, with `after` as the key
/// after it. Every key a link names is in the index, so `found` is never
/// `None`.
fn with_after<K, V>(found: Option<Entry<K, V>>, after: Option<K>) -> Entry<K, V> {
  case found {
    Some(entry) => Entry { ..entry, after }
    None => panic as "an ordered map links to a key it does not hold"
  }
}

/// `found`, the entry of a key that a link names, with `before` as the
/// key before it, as in `with_after`.
fn with_before<K, V>(found: Option<Entry<K, V>>, before: Option<K>) -> Entry<K, V> {
  case found {
    Some(entry) => Entry { ..entry, before }
    None => panic as "an ordered map links to a key it does not hold"
  }
}

/// The map of `index`, which already holds `key` as a new key whose
/// entry follows `newest`: `newest`'s entry gets `key` after it, and
/// `key` becomes the newest key, and the oldest too in a map that was
/// empty.
fn link_newest<K, V>(
  index: map::Map<K, Entry<K, V>>,
  oldest: Option<K>,
  newest: Option<K>,
  key: K,
) -> OrderedMap<K, V> {
  let added = Some(key)
  case newest {
    Some(previous) => OrderedMap {
      index: map::upsert(index, previous, fn(found) { with_after(found, added) }),
      oldest,
      newest: added,
    }
    None => OrderedMap { index, oldest: added, newest: added }
  }
}

/// Returns the map with `value` stored under `key`. A new key goes at the
/// end, and a key already present keeps its place (D-340).
pub fn insert<K, V>(m: OrderedMap<K, V>, key: K, value: V) -> OrderedMap<K, V> {
  let OrderedMap { index, oldest, newest } = m
  let held = map::size(index)
  let changed = map::upsert(index, key, fn(found) {
    case found {
      Some(entry) => Entry { ..entry, value }
      None => Entry { before: newest, after: None, value }
    }
  })
  case map::size(changed) == held {
    True => OrderedMap { index: changed, oldest, newest }
    False => link_newest(changed, oldest, newest, key)
  }
}

test "insert adds at the end and replaces in place" {
  let start = from_list([("b", 1), ("a", 2)])
  let added = insert(start, "c", 3)
  let replaced = insert(added, "b", 10)
  assert to_list(added) == [("b", 1), ("a", 2), ("c", 3)]
  assert to_list(replaced) == [("b", 10), ("a", 2), ("c", 3)]
  assert to_list(start) == [("b", 1), ("a", 2)]
}

/// Returns the map without `key`, or unchanged when `key` is not in it.
/// The other keys keep their order, and a removed key inserted again goes
/// at the end (D-340). The keys before and after `key` are linked to each
/// other, or become an end of the order.
pub fn remove<K, V>(m: OrderedMap<K, V>, key: K) -> OrderedMap<K, V> {
  case map::get(m.index, key) {
    Some(Entry { before, after, .. }) => {
      let OrderedMap { index, oldest, newest } = m
      let dropped = map::remove(index, key)
      let forward = case before {
        Some(previous) => map::upsert(dropped, previous, fn(found) { with_after(found, after) })
        None => dropped
      }
      let linked = case after {
        Some(following) => map::upsert(forward, following, fn(found) { with_before(found, before) })
        None => forward
      }
      let first_key = case before {
        Some(_) => oldest
        None => after
      }
      let last_key = case after {
        Some(_) => newest
        None => before
      }
      OrderedMap { index: linked, oldest: first_key, newest: last_key }
    }
    None => m
  }
}

test "remove then insert moves a key to the end" {
  let start = from_list([("a", 1), ("b", 2), ("c", 3)])
  let removed = remove(start, "a")
  let back = insert(removed, "a", 1)
  assert keys(removed) == ["b", "c"]
  assert keys(back) == ["b", "c", "a"]
  assert back != start
  assert remove(start, "z") == start
}

/// Calls `update` once with the value under `key`, if any, and stores its
/// result there. A key already present keeps its place, and a new key goes
/// at the end (D-340).
pub fn upsert<K, V>(m: OrderedMap<K, V>, key: K, update: fn(Option<V>) -> V) -> OrderedMap<K, V> {
  // On an index held only here, `map::upsert` moves the stored entry into
  // its callback, so `update` gets the value unshared and can change it in
  // place.
  let OrderedMap { index, oldest, newest } = m
  let held = map::size(index)
  let changed = map::upsert(index, key, fn(found) {
    case found {
      Some(Entry { before, after, value }) => Entry { before, after, value: update(Some(value)) }
      None => Entry { before: newest, after: None, value: update(None) }
    }
  })
  case map::size(changed) == held {
    True => OrderedMap { index: changed, oldest, newest }
    False => link_newest(changed, oldest, newest, key)
  }
}

test "upsert keeps the position of an existing key" {
  fn bump(previous: Option<Int>) -> Int {
    case previous {
      Some(n) => n + 1
      None => 1
    }
  }
  let words = ["to", "be", "or", "not", "to", "be"]
  let counts = list::fold(words, new(), fn(acc, word) { upsert(acc, word, bump) })
  assert to_list(counts) == [("to", 2), ("be", 2), ("or", 1), ("not", 1)]
}

/// Returns the entries of both maps, as if each entry of `other` were
/// inserted into `m` in `other`'s order: a shared key keeps its place in
/// `m` and takes the value from `other`, and the keys only in `other`
/// follow (D-340).
pub fn merge<K, V>(m: OrderedMap<K, V>, other: OrderedMap<K, V>) -> OrderedMap<K, V> {
  fold(other, m, fn(merged, key, value) { insert(merged, key, value) })
}

test "merge appends new keys and replaces shared ones in place" {
  let base = from_list([("b", 1), ("a", 2)])
  let changes = from_list([("c", 30), ("b", 10)])
  assert to_list(merge(base, changes)) == [("b", 10), ("a", 2), ("c", 30)]
}

// Iterating

/// Returns the keys in the map's order, O(n).
pub fn keys<K, V>(m: OrderedMap<K, V>) -> List<K> {
  fold(m, [], fn(found, key, _) { list::push(found, key) })
}

test "keys come in insertion order" {
  let scores = from_list([("b", 2), ("c", 3), ("a", 1)])
  assert keys(scores) == ["b", "c", "a"]
}

/// Returns the values in the order of their keys.
pub fn values<K, V>(m: OrderedMap<K, V>) -> List<V> {
  fold(m, [], fn(found, _, value) { list::push(found, value) })
}

test "values follow the order of their keys" {
  let scores = from_list([("b", 2), ("c", 3), ("a", 1)])
  assert values(scores) == [2, 3, 1]
}

/// Returns the entries as pairs, in the map's order. Like every walk, it
/// follows the links from the oldest key and looks each key up in `index`:
/// n lookups, each O(log n) and effectively constant, so the walk is O(n)
/// in the same sense as `Map`'s costs (D-848).
pub fn to_list<K, V>(m: OrderedMap<K, V>) -> List<(K, V)> {
  fold(m, [], fn(found, key, value) { list::push(found, (key, value)) })
}

test "to_list gives the entries in insertion order" {
  let scores = from_list([("b", 2), ("a", 1)])
  assert to_list(scores) == [("b", 2), ("a", 1)]
}

/// Combines the entries in the map's order, starting from `initial`. Like
/// `to_list`, it looks each key up, effectively O(1) per entry (D-848).
pub fn fold<K, V, A>(m: OrderedMap<K, V>, initial: A, f: fn(A, K, V) -> A) -> A {
  fold_from(m.index, m.oldest, initial, f)
}

/// Combines the entries from `at` to the end of the order, starting from
/// `found`. The call to itself is a tail call, so the stack stays flat
/// however long the map is (D-015).
fn fold_from<K, V, A>(
  index: map::Map<K, Entry<K, V>>,
  at: Option<K>,
  found: A,
  f: fn(A, K, V) -> A,
) -> A {
  case at {
    Some(key) => case map::get(index, key) {
      Some(entry) => fold_from(index, entry.after, f(found, key, entry.value), f)
      None => found
    }
    None => found
  }
}

test "fold visits the keys in insertion order" {
  let scores = from_list([("b", 2), ("c", 3), ("a", 1)])
  assert fold(scores, "", fn(text, key, _) { text + key }) == "bca"
}

/// Calls `f` once per entry, in the map's order, for its effects.
pub fn each<K, V>(m: OrderedMap<K, V>, f: fn(K, V)) {
  fold(m, Nil, fn(_, key, value) { f(key, value) })
}

test "each calls the function once per entry" {
  let lengths = from_list([("bb", 2), ("a", 1)])
  each(lengths, fn(key, value) { assert string::length(key) == value })
}

/// Combines the entries in the map's order like `fold`, and stops at the
/// first `Err` that `f` returns (D-1080, D-1082). It follows the links
/// and looks each key up, as `fold` does (D-848), so a walk that stops
/// after k entries takes O(k).
pub fn try_fold<K, V, A, E>(
  m: OrderedMap<K, V>,
  initial: A,
  f: fn(A, K, V) -> Result<A, E>,
) -> Result<A, E> {
  try_fold_from(m.index, m.oldest, initial, f)
}

/// Combines the entries from `at` on like `fold_from`, and stops at the
/// first `Err` that `f` returns. The call to itself is a tail call.
fn try_fold_from<K, V, A, E>(
  index: map::Map<K, Entry<K, V>>,
  at: Option<K>,
  found: A,
  f: fn(A, K, V) -> Result<A, E>,
) -> Result<A, E> {
  case at {
    Some(key) => case map::get(index, key) {
      Some(entry) => case f(found, key, entry.value) {
        Ok(stepped) => try_fold_from(index, entry.after, stepped, f)
        Err(reason) => Err(reason)
      }
      None => Ok(found)
    }
    None => Ok(found)
  }
}

test "try_fold stops at the first error" {
  fn add_small(total: Int, key: String, value: Int) -> Result<Int, String> {
    case value < 10 {
      True => Ok(total + value)
      False => Err(key)
    }
  }
  let scores = from_list([("b", 2), ("c", 30), ("a", 40)])
  assert try_fold(scores, 0, add_small) == Err("c")
  let small = remove(remove(scores, "c"), "a")
  assert try_fold(small, 0, add_small) == Ok(2)
  assert try_fold(new(), 7, add_small) == Ok(7)
  let stops = try_fold(scores, 0, fn(total, key, value) {
    case key {
      "a" => panic as "not reached"
      "c" => Err(total)
      _ => Ok(total + value)
    }
  })
  assert stops == Err(2)
}

/// Tells whether `predicate` returns `True` for some entry, in the map's
/// order, stopping at the first such entry (D-1082).
pub fn any<K, V>(m: OrderedMap<K, V>, predicate: fn(K, V) -> Bool) -> Bool {
  case find(m, predicate) {
    Some(_) => True
    None => False
  }
}

test "any stops at the first match" {
  let scores = from_list([("b", 2), ("c", 3), ("a", 1)])
  assert any(scores, fn(key, value) {
    case key {
      "a" => panic as "not reached"
      _ => value == 3
    }
  })
  assert !any(scores, fn(_, value) { value > 3 })
  assert !any(new::<String, Int>(), fn(_, _) { True })
}

/// Tells whether `predicate` returns `True` for every entry, in the map's
/// order, stopping at the first entry for which it returns `False` (D-1082).
pub fn all<K, V>(m: OrderedMap<K, V>, predicate: fn(K, V) -> Bool) -> Bool {
  let walked = try_fold(m, Nil, fn(_, key, value) {
    case predicate(key, value) {
      True => Ok(Nil)
      False => Err(Nil)
    }
  })
  walked == Ok(Nil)
}

test "all needs every entry to match" {
  let scores = from_list([("b", 2), ("c", 3), ("a", 1)])
  assert all(scores, fn(_, value) { value > 0 })
  assert !all(scores, fn(key, value) {
    case key {
      "a" => panic as "not reached"
      _ => value < 3
    }
  })
  assert all(new::<String, Int>(), fn(_, _) { False })
}

/// Returns the first entry in the map's order for which `predicate`
/// returns `True`, stopping there (D-1082).
pub fn find<K, V>(m: OrderedMap<K, V>, predicate: fn(K, V) -> Bool) -> Option<(K, V)> {
  let walked = try_fold(m, Nil, fn(_, key, value) {
    case predicate(key, value) {
      True => Err((key, value))
      False => Ok(Nil)
    }
  })
  case walked {
    Err(found) => Some(found)
    Ok(_) => None
  }
}

test "find returns the first match in insertion order" {
  let scores = from_list([("b", 2), ("c", 3), ("a", 1)])
  assert find(scores, fn(_, value) { value != 2 }) == Some(("c", 3))
  assert find(scores, fn(_, value) { value > 3 }) == None
}

// Transforming

/// Returns a map with the same keys in the same order, each value replaced
/// by `f` of its key and value. `f` is called once per entry, in the map's
/// order. Each key keeps its links.
pub fn map_values<K, V, W>(m: OrderedMap<K, V>, f: fn(K, V) -> W) -> OrderedMap<K, W> {
  let mapped = map_from(m.index, m.oldest, map::new(), f)
  OrderedMap { index: mapped, oldest: m.oldest, newest: m.newest }
}

/// `mapped` with the entries from `at` to the end of the order added, each
/// with its links and `f` of its key and value. The call to itself is a
/// tail call.
fn map_from<K, V, W>(
  index: map::Map<K, Entry<K, V>>,
  at: Option<K>,
  mapped: map::Map<K, Entry<K, W>>,
  f: fn(K, V) -> W,
) -> map::Map<K, Entry<K, W>> {
  case at {
    Some(key) => case map::get(index, key) {
      Some(Entry { before, after, value }) => {
        let entry = Entry { before, after, value: f(key, value) }
        map_from(index, after, map::insert(mapped, key, entry), f)
      }
      None => mapped
    }
    None => mapped
  }
}

test "map_values keeps the keys and their order" {
  let counts = from_list([("b", 2), ("a", 1)])
  let labels = map_values(counts, fn(key, value) { "{key}={value}" })
  assert to_list(labels) == [("b", "b=2"), ("a", "a=1")]
}

/// Returns the entries for which `keep` returns `True`, in the same order.
/// `keep` is called once per entry, in the map's order, and each entry it
/// drops is removed, O(n log n).
pub fn filter<K, V>(m: OrderedMap<K, V>, keep: fn(K, V) -> Bool) -> OrderedMap<K, V> {
  fold(m, m, fn(kept, key, value) {
    case keep(key, value) {
      True => kept
      False => remove(kept, key)
    }
  })
}

test "filter keeps the matching entries in order" {
  let counts = from_list([("c", 3), ("b", 2), ("a", 1)])
  let odd = filter(counts, fn(_, value) { value % 2 == 1 })
  assert keys(odd) == ["c", "a"]
}

// Text

/// Writes `ordered_map::from_list([`, the entries in the map's order as
/// pairs written with `show`, and `])` (D-355). It makes `OrderedMap<K, V>`
/// satisfy `Show` when `K` and `V` do (D-064, D-344).
pub fn show<K: Show, V: Show>(m: OrderedMap<K, V>) -> String {
  let pairs = to_list(m)
  "ordered_map::from_list({pairs})"
}

test "an ordered map shows its entries in order" {
  let scores = from_list([("b", 2), ("a", 1)])
  assert show(scores) == "ordered_map::from_list([(b, 2), (a, 1)])"
  assert "{scores}" == "ordered_map::from_list([(b, 2), (a, 1)])"
}

// Internal tests

test "a key keeps its place through updates" {
  let start = from_list([("a", 1), ("b", 2)])
  let updated = upsert(insert(start, "a", 10), "a", fn(found) {
    case found {
      Some(n) => n + 1
      None => 0
    }
  })
  assert keys(updated) == ["a", "b"]
  assert get(updated, "a") == Some(11)
  assert (updated.oldest, updated.newest) == (Some("a"), Some("b"))
}

test "upsert gives update the stored value and leaves the old map as it was" {
  let start = from_list([("a", [1]), ("b", [2])])
  fn append(found: Option<List<Int>>) -> List<Int> {
    case found {
      Some(items) => list::push(items, 3)
      None => [0]
    }
  }
  let grown = upsert(start, "a", append)
  let added = upsert(grown, "c", append)
  assert to_list(start) == [("a", [1]), ("b", [2])]
  assert to_list(grown) == [("a", [1, 3]), ("b", [2])]
  assert to_list(added) == [("a", [1, 3]), ("b", [2]), ("c", [0])]
  assert (start.newest, grown.newest, added.newest) == (Some("b"), Some("b"), Some("c"))
  assert map::size(added.index) == 3
}

test "insert links only new keys" {
  let start = from_list([("a", 1), ("b", 2)])
  let replaced = insert(start, "a", 10)
  let added = insert(replaced, "c", 3)
  assert (replaced.oldest, replaced.newest) == (Some("a"), Some("b"))
  assert (added.oldest, added.newest) == (Some("a"), Some("c"))
  assert to_list(added) == [("a", 10), ("b", 2), ("c", 3)]
  assert to_list(start) == [("a", 1), ("b", 2)]
}

test "upserts of a growing list keep every value and the order" {
  let numbers = list::map(list::range(0, 2000), fn(n) { n % 7 })
  let built = list::fold(numbers, new(), fn(acc, key) {
    upsert(acc, key, fn(found) {
      case found {
        Some(items) => list::push(items, key)
        None => [key]
      }
    })
  })
  assert keys(built) == [0, 1, 2, 3, 4, 5, 6]
  assert list::map(values(built), list::length) == [286, 286, 286, 286, 286, 285, 285]
  assert (built.oldest, built.newest) == (Some(0), Some(6))
}

test "removing any entry keeps the links both ways" {
  // The keys from the newest to the oldest, following `before`.
  fn backward(
    index: map::Map<Int, Entry<Int, Int>>,
    at: Option<Int>,
    found: List<Int>,
  ) -> List<Int> {
    case at {
      Some(key) => case map::get(index, key) {
        Some(entry) => backward(index, entry.before, list::push(found, key))
        None => found
      }
      None => found
    }
  }
  // Whether both walks give the same keys, `oldest` and `newest` are
  // their ends, and the index holds nothing else.
  fn linked(m: OrderedMap<Int, Int>) -> Bool {
    let forward = keys(m)
    let ends = (list::first(forward), list::last(forward))
    backward(m.index, m.newest, []) == list::reverse(forward)
      && (m.oldest, m.newest) == ends
      && list::length(forward) == map::size(m.index)
  }
  let start = from_list([(1, 10), (2, 20), (3, 30), (4, 40)])
  let no_first = remove(start, 1)
  let no_last = remove(start, 4)
  let no_middle = remove(start, 2)
  let only = from_list([(5, 50)])
  let emptied = remove(only, 5)
  assert keys(no_first) == [2, 3, 4]
  assert keys(no_last) == [1, 2, 3]
  assert keys(no_middle) == [1, 3, 4]
  assert linked(start) && linked(no_first) && linked(no_last) && linked(no_middle)
  assert linked(remove(remove(no_middle, 3), 1))
  assert linked(only) && linked(emptied)
  assert (emptied.oldest, emptied.newest) == (None, None)
  assert map::is_empty(emptied.index)
  assert linked(insert(emptied, 6, 60))
  assert first(no_first) == Some((2, 20))
  assert last(no_last) == Some((3, 30))
  assert keys(start) == [1, 2, 3, 4]
}

test "remove then insert links the key at the end" {
  let start = from_list([(1, 10), (2, 20), (3, 30)])
  let moved = insert(remove(start, 2), 2, 21)
  let moved_first = insert(remove(moved, 1), 1, 11)
  assert to_list(moved) == [(1, 10), (3, 30), (2, 21)]
  assert to_list(moved_first) == [(3, 30), (2, 21), (1, 11)]
  assert (moved_first.oldest, moved_first.newest) == (Some(3), Some(1))
  assert to_list(start) == [(1, 10), (2, 20), (3, 30)]
}

test "maps built by different histories hold the same fields" {
  let listed = from_list([("a", 1), ("b", 2), ("c", 3)])
  let start = from_list([("z", 0), ("a", 1), ("b", 0)])
  let churned = start
    |> remove(_, "z")
    |> insert(_, "b", 2)
    |> remove(_, "c")
    |> insert(_, "c", 3)
    |> insert(_, "b", 2)
  assert listed == churned
  assert (listed.index, listed.oldest, listed.newest) ==
    (churned.index, churned.oldest, churned.newest)
  assert listed != from_list([("a", 1), ("c", 3), ("b", 2)])
}

test "a long map keeps its order through removals" {
  let numbers = list::range(0, 1000)
  let built = from_list(list::map(numbers, fn(n) { (999 - n, n) }))
  let odd = filter(built, fn(key, _) { key % 2 == 1 })
  assert size(odd) == 500
  assert first(odd) == Some((999, 0))
  assert last(odd) == Some((1, 998))
  assert keys(odd) == list::filter(list::map(numbers, fn(n) { 999 - n }), fn(key) { key % 2 == 1 })
  assert from_list(to_list(odd)) == odd
}

test "a large map is walked without growing the stack" {
  let numbers = list::range(0, 50_000)
  let built = from_list(list::map(numbers, fn(n) { (n, n * 2) }))
  assert fold(built, 0, fn(sum, key, value) { sum + key + value }) == 3_749_925_000
  assert list::length(keys(built)) == 50_000
  assert try_fold(built, 0, fn(seen, _, _) { Ok(seen + 1) }) == Ok::<Int, Nil>(50_000)
  assert find(built, fn(key, _) { key == 49_999 }) == Some((49_999, 99_998))
  assert last(map_values(built, fn(key, _) { key })) == Some((49_999, 49_999))
}

// Puzzle helpers. They sit at the end of the file, so no std location that
// a golden pins moves (D-1603).

/// Returns the value stored under `key`, or `default` when `key` is not
/// in the map (D-1648, D-1659).
pub fn get_or<K, V>(m: OrderedMap<K, V>, key: K, default: V) -> V {
  case get(m, key) {
    Some(value) => value
    None => default
  }
}

test "get_or falls back for a missing key" {
  let ages = from_list([("ada", 36), ("alan", 41)])
  assert get_or(ages, "ada", 0) == 36
  assert get_or(ages, "grace", 0) == 0
  assert get_or(new::<String, Int>(), "ada", -1) == -1
}

/// Returns the number of entries for which `predicate` returns `True`,
/// calling it once per entry in the map's order (D-1659).
pub fn count<K, V>(m: OrderedMap<K, V>, predicate: fn(K, V) -> Bool) -> Int {
  fold(m, 0, fn(found, key, value) {
    case predicate(key, value) {
      True => found + 1
      False => found
    }
  })
}

test "count counts the matching entries" {
  let scores = from_list([("b", 2), ("c", 3), ("a", 1)])
  assert count(scores, fn(_, value) { value > 1 }) == 2
  assert count(scores, fn(key, _) { key == "z" }) == 0
  assert count(new::<String, Int>(), fn(_, _) { True }) == 0
}
