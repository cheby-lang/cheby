//! The built-in `I16`, a signed 16-bit integer: constants, conversions,
//! parsing and text, comparison, and checked and wrapping arithmetic
//! (the integer families of `docs/stdlib/README.md`, D-350).
//!
//! `I16` itself is a builtin item whose home module is this one (D-447).

import std::int

// Constants

/// The smallest `I16`.
pub const min_value: I16 = -32_768

/// The largest `I16`.
pub const max_value: I16 = 32_767

// Conversions

/// Returns `n` as an `I16`, or `Err(Nil)` when it does not fit.
@external(native, "cheby_i16_from_int")
@external(js, "./i16.mjs", "from_int")
pub fn from_int(n: Int) -> Result<I16, Nil>

/// Returns `n` as an `I16`. Every `I8` fits.
@external(native, "cheby_i16_from_i8")
@external(js, "./i16.mjs", "from_i8")
pub fn from_i8(n: I8) -> I16

/// Returns `n` as an `I16`, or `Err(Nil)` when it does not fit.
@external(native, "cheby_i16_from_i32")
@external(js, "./i16.mjs", "from_i32")
pub fn from_i32(n: I32) -> Result<I16, Nil>

/// Returns `n` as an `I16`, or `Err(Nil)` when it does not fit.
@external(native, "cheby_i16_from_i64")
@external(js, "./i16.mjs", "from_i64")
pub fn from_i64(n: I64) -> Result<I16, Nil>

/// Returns `n` as an `I16`. Every `U8` fits.
@external(native, "cheby_i16_from_u8")
@external(js, "./i16.mjs", "from_u8")
pub fn from_u8(n: U8) -> I16

/// Returns `n` as an `I16`, or `Err(Nil)` when it does not fit.
@external(native, "cheby_i16_from_u16")
@external(js, "./i16.mjs", "from_u16")
pub fn from_u16(n: U16) -> Result<I16, Nil>

/// Returns `n` as an `I16`, or `Err(Nil)` when it does not fit.
@external(native, "cheby_i16_from_u32")
@external(js, "./i16.mjs", "from_u32")
pub fn from_u32(n: U32) -> Result<I16, Nil>

/// Returns `n` as an `I16`, or `Err(Nil)` when it does not fit.
@external(native, "cheby_i16_from_u64")
@external(js, "./i16.mjs", "from_u64")
pub fn from_u64(n: U64) -> Result<I16, Nil>

/// Keeps the low 16 bits of `n`'s two's-complement value and reads them as an `I16` (D-1091).
pub fn wrapping_from_int(n: Int) -> I16 {
  let low = n & 0xFFFF
  case low < 0x8000 {
    True => {
      let assert Ok(value) = from_int(low)
      value
    }
    False => {
      // `0xFFFF - low` fits, and minus it minus 1 is `low` - 2^16.
      let assert Ok(complement) = from_int(0xFFFF - low)
      -complement - 1
    }
  }
}

/// Keeps the low 16 bits of `n`'s two's-complement value and reads them as an `I16` (D-1091).
pub fn wrapping_from_i32(n: I32) -> I16 {
  let low = n & 0xFFFF
  case low < 0x8000 {
    True => {
      let assert Ok(value) = from_i32(low)
      value
    }
    False => {
      // `0xFFFF - low` fits, and minus it minus 1 is `low` - 2^16.
      let assert Ok(complement) = from_i32(0xFFFF - low)
      -complement - 1
    }
  }
}

/// Keeps the low 16 bits of `n`'s two's-complement value and reads them as an `I16` (D-1091).
pub fn wrapping_from_i64(n: I64) -> I16 {
  let low = n & 0xFFFF
  case low < 0x8000 {
    True => {
      let assert Ok(value) = from_i64(low)
      value
    }
    False => {
      // `0xFFFF - low` fits, and minus it minus 1 is `low` - 2^16.
      let assert Ok(complement) = from_i64(0xFFFF - low)
      -complement - 1
    }
  }
}

/// Keeps the low 16 bits of `n`'s two's-complement value and reads them as an `I16` (D-1091).
pub fn wrapping_from_u16(n: U16) -> I16 {
  case n < 0x8000 {
    True => {
      let assert Ok(value) = from_u16(n)
      value
    }
    False => {
      // `0xFFFF - n` fits, and minus it minus 1 is `n` - 2^16.
      let assert Ok(complement) = from_u16(0xFFFF - n)
      -complement - 1
    }
  }
}

/// Keeps the low 16 bits of `n`'s two's-complement value and reads them as an `I16` (D-1091).
pub fn wrapping_from_u32(n: U32) -> I16 {
  let low = n & 0xFFFF
  case low < 0x8000 {
    True => {
      let assert Ok(value) = from_u32(low)
      value
    }
    False => {
      // `0xFFFF - low` fits, and minus it minus 1 is `low` - 2^16.
      let assert Ok(complement) = from_u32(0xFFFF - low)
      -complement - 1
    }
  }
}

/// Keeps the low 16 bits of `n`'s two's-complement value and reads them as an `I16` (D-1091).
pub fn wrapping_from_u64(n: U64) -> I16 {
  let low = n & 0xFFFF
  case low < 0x8000 {
    True => {
      let assert Ok(value) = from_u64(low)
      value
    }
    False => {
      // `0xFFFF - low` fits, and minus it minus 1 is `low` - 2^16.
      let assert Ok(complement) = from_u64(0xFFFF - low)
      -complement - 1
    }
  }
}

test "wrapping_from keeps the low 16 bits of every source" {
  assert wrapping_from_int(-32_769) == 32_767
  assert wrapping_from_int(-32_768) == -32_768
  assert wrapping_from_int(-1) == -1
  assert wrapping_from_int(0) == 0
  assert wrapping_from_int(1) == 1
  assert wrapping_from_int(32_767) == 32_767
  assert wrapping_from_int(32_768) == -32_768
  assert wrapping_from_i32(-2_147_483_648) == 0
  assert wrapping_from_i32(-1_985_229_329) == -12_817
  assert wrapping_from_i32(-32_769) == 32_767
  assert wrapping_from_i32(-32_768) == -32_768
  assert wrapping_from_i32(-1) == -1
  assert wrapping_from_i32(0) == 0
  assert wrapping_from_i32(1) == 1
  assert wrapping_from_i32(32_767) == 32_767
  assert wrapping_from_i32(32_768) == -32_768
  assert wrapping_from_i32(1_985_229_329) == 12_817
  assert wrapping_from_i32(2_147_483_647) == -1
  assert wrapping_from_i64(-9_223_372_036_854_775_808) == 0
  assert wrapping_from_i64(-81_985_529_216_486_895) == 12_817
  assert wrapping_from_i64(-32_769) == 32_767
  assert wrapping_from_i64(-32_768) == -32_768
  assert wrapping_from_i64(-1) == -1
  assert wrapping_from_i64(0) == 0
  assert wrapping_from_i64(1) == 1
  assert wrapping_from_i64(32_767) == 32_767
  assert wrapping_from_i64(32_768) == -32_768
  assert wrapping_from_i64(81_985_529_216_486_895) == -12_817
  assert wrapping_from_i64(9_223_372_036_854_775_807) == -1
  assert wrapping_from_u16(0) == 0
  assert wrapping_from_u16(1) == 1
  assert wrapping_from_u16(32_767) == 32_767
  assert wrapping_from_u16(32_768) == -32_768
  assert wrapping_from_u16(52_719) == -12_817
  assert wrapping_from_u16(65_535) == -1
  assert wrapping_from_u32(0) == 0
  assert wrapping_from_u32(1) == 1
  assert wrapping_from_u32(32_767) == 32_767
  assert wrapping_from_u32(32_768) == -32_768
  assert wrapping_from_u32(2_309_737_967) == -12_817
  assert wrapping_from_u32(4_294_967_295) == -1
  assert wrapping_from_u64(0) == 0
  assert wrapping_from_u64(1) == 1
  assert wrapping_from_u64(32_767) == 32_767
  assert wrapping_from_u64(32_768) == -32_768
  assert wrapping_from_u64(81_985_529_216_486_895) == -12_817
  assert wrapping_from_u64(18_446_744_073_709_551_615) == -1
}

@target(native)
test "wrapping_from_int keeps the low 16 bits of every Int" {
  assert wrapping_from_int(-9_223_372_036_854_775_808) == 0
  assert wrapping_from_int(-81_985_529_216_486_895) == 12_817
  assert wrapping_from_int(81_985_529_216_486_895) == -12_817
  assert wrapping_from_int(9_223_372_036_854_775_807) == -1
}

// Parsing and text

/// Reads an `I16` written as an optional `-` and ASCII decimal digits (D-312).
@external(native, "cheby_i16_parse")
@external(js, "./i16.mjs", "parse")
pub fn parse(text: String) -> Result<I16, Nil>

/// Reads an `I16` written in `base`, from 2 to 36, as an optional `-` and digits.
@external(native, "cheby_i16_parse_base")
@external(js, "./i16.mjs", "parse_base")
pub fn parse_base(text: String, base: Int) -> Result<I16, Nil>

/// Returns `n` written in `base`, from 2 to 36, in lowercase digits (D-390, D-1090).
pub fn to_base(n: I16, base: Int) -> Result<String, Nil> {
  int::to_base(int::from_i16(n), base)
}

test "to_base writes every I16 in every base" {
  assert to_base(-32_768, 2) == Ok("-1000000000000000")
  assert to_base(-32_768, 8) == Ok("-100000")
  assert to_base(-32_768, 10) == Ok("-32768")
  assert to_base(-32_768, 16) == Ok("-8000")
  assert to_base(-32_768, 36) == Ok("-pa8")
  assert to_base(-32_767, 2) == Ok("-111111111111111")
  assert to_base(-32_767, 8) == Ok("-77777")
  assert to_base(-32_767, 10) == Ok("-32767")
  assert to_base(-32_767, 16) == Ok("-7fff")
  assert to_base(-32_767, 36) == Ok("-pa7")
  assert to_base(-12_817, 2) == Ok("-11001000010001")
  assert to_base(-12_817, 8) == Ok("-31021")
  assert to_base(-12_817, 10) == Ok("-12817")
  assert to_base(-12_817, 16) == Ok("-3211")
  assert to_base(-12_817, 36) == Ok("-9w1")
  assert to_base(-1, 2) == Ok("-1")
  assert to_base(-1, 8) == Ok("-1")
  assert to_base(-1, 10) == Ok("-1")
  assert to_base(-1, 16) == Ok("-1")
  assert to_base(-1, 36) == Ok("-1")
  assert to_base(0, 2) == Ok("0")
  assert to_base(0, 8) == Ok("0")
  assert to_base(0, 10) == Ok("0")
  assert to_base(0, 16) == Ok("0")
  assert to_base(0, 36) == Ok("0")
  assert to_base(1, 2) == Ok("1")
  assert to_base(1, 8) == Ok("1")
  assert to_base(1, 10) == Ok("1")
  assert to_base(1, 16) == Ok("1")
  assert to_base(1, 36) == Ok("1")
  assert to_base(32_767, 2) == Ok("111111111111111")
  assert to_base(32_767, 8) == Ok("77777")
  assert to_base(32_767, 10) == Ok("32767")
  assert to_base(32_767, 16) == Ok("7fff")
  assert to_base(32_767, 36) == Ok("pa7")
  assert to_base(max_value, 0) == Err(Nil)
  assert to_base(max_value, -16) == Err(Nil)
  assert to_base(min_value, 37) == Err(Nil)
}

/// Returns `n` in decimal. It makes `I16` satisfy `Show`.
@external(native, "cheby_i16_show")
@external(js, "./i16.mjs", "show")
pub fn show(n: I16) -> String

// Comparison

/// Orders two `I16` values. It makes `I16` satisfy `Compare`.
pub fn compare(a: I16, b: I16) -> Order {
  case {
    a < b => Less
    a > b => Greater
    _ => Equal
  }
}

/// Returns the smaller of `a` and `b`, and `a` when they are `Equal`.
pub fn min(a: I16, b: I16) -> I16 {
  case {
    b < a => b
    _ => a
  }
}

/// Returns the larger of `a` and `b`, and `a` when they are `Equal`.
pub fn max(a: I16, b: I16) -> I16 {
  case {
    b > a => b
    _ => a
  }
}

// Arithmetic

/// Returns `a + b`, and panics when the result does not fit. It makes `I16` satisfy `Add`.
pub fn add(a: I16, b: I16) -> I16 {
  a + b
}

/// Returns `a - b`, and panics when the result does not fit. It makes `I16` satisfy `Sub`.
pub fn sub(a: I16, b: I16) -> I16 {
  a - b
}

/// Returns `a * b`, and panics when the result does not fit. It makes `I16` satisfy `Mul`.
pub fn mul(a: I16, b: I16) -> I16 {
  a * b
}

/// Returns `a / b` toward zero, panicking like `/`. It makes `I16` satisfy `Div`.
pub fn div(a: I16, b: I16) -> I16 {
  a / b
}

/// Returns `a % b`, with the sign of `a`, and panics on a zero divisor.
pub fn rem(a: I16, b: I16) -> I16 {
  a % b
}

/// Returns `-n`, and panics when it does not fit. It makes `I16` satisfy `Neg`.
pub fn neg(n: I16) -> I16 {
  -n
}

/// Returns `n` without its sign, and panics for `min_value`, like `neg`.
pub fn abs(n: I16) -> I16 {
  case {
    n < 0 => -n
    _ => n
  }
}

// Checked arithmetic

/// Returns `Ok(a + b)`, or `Err(Nil)` when the sum does not fit (D-309).
@external(native, "cheby_i16_checked_add")
@external(js, "./i16.mjs", "checked_add")
pub fn checked_add(a: I16, b: I16) -> Result<I16, Nil>

/// Returns `Ok(a - b)`, or `Err(Nil)` when the difference does not fit (D-309).
@external(native, "cheby_i16_checked_sub")
@external(js, "./i16.mjs", "checked_sub")
pub fn checked_sub(a: I16, b: I16) -> Result<I16, Nil>

/// Returns `Ok(a * b)`, or `Err(Nil)` when the product does not fit (D-309).
@external(native, "cheby_i16_checked_mul")
@external(js, "./i16.mjs", "checked_mul")
pub fn checked_mul(a: I16, b: I16) -> Result<I16, Nil>

/// Returns `Ok(a / b)`, or `Err(Nil)` for a zero divisor and for `min_value / -1` (D-356).
pub fn checked_div(a: I16, b: I16) -> Result<I16, Nil> {
  // Dividing by -1 overflows exactly when negating does.
  case b {
    0 => Err(Nil)
    -1 => checked_neg(a)
    _ => Ok(a / b)
  }
}

/// Returns `Ok(a % b)`, or `Err(Nil)` for a zero divisor (D-356).
pub fn checked_rem(a: I16, b: I16) -> Result<I16, Nil> {
  case b {
    0 => Err(Nil)
    _ => Ok(a % b)
  }
}

/// Returns `Ok(-n)`, or `Err(Nil)` for `min_value` (D-309).
pub fn checked_neg(n: I16) -> Result<I16, Nil> {
  case {
    n == min_value => Err(Nil)
    _ => Ok(-n)
  }
}

// Wrapping arithmetic

/// Returns `a + b` modulo 2^16 (D-025).
@external(native, "cheby_i16_wrapping_add")
@external(js, "./i16.mjs", "wrapping_add")
pub fn wrapping_add(a: I16, b: I16) -> I16

/// Returns `a - b` modulo 2^16 (D-025).
@external(native, "cheby_i16_wrapping_sub")
@external(js, "./i16.mjs", "wrapping_sub")
pub fn wrapping_sub(a: I16, b: I16) -> I16

/// Returns `a * b` modulo 2^16 (D-025).
@external(native, "cheby_i16_wrapping_mul")
@external(js, "./i16.mjs", "wrapping_mul")
pub fn wrapping_mul(a: I16, b: I16) -> I16

/// Returns `-n` modulo 2^16 (D-025).
@external(native, "cheby_i16_wrapping_neg")
@external(js, "./i16.mjs", "wrapping_neg")
pub fn wrapping_neg(n: I16) -> I16

// Examples

test "the i16 range" {
  assert min_value == -32_768
  assert max_value == 32_767
}

test "conversions to i16" {
  assert from_i8(-128) == -128
  assert from_u8(255) == 255
  assert from_int(32_768) == Err(Nil)
  assert from_i32(-32_768) == Ok(-32_768)
  assert from_u16(65_535) == Err(Nil)
  assert wrapping_from_u64(0x0123_4567_89AB_CDEF) == -12_817
  assert wrapping_from_int(-1) == -1
  assert wrapping_from_u16(65_535) == -1
  assert wrapping_from_int(32_840) == -32_696
}

test "i16 parses and shows decimal digits" {
  let small: I16 = -5
  assert parse("-32768") == Ok(-32_768)
  assert parse("32768") == Err(Nil)
  assert parse_base("-1010", 2) == Ok(-10)
  assert show(min_value) == "-32768"
  assert "{small}" == "-5"
  assert to_base(max_value, 16) == Ok("7fff")
  assert to_base(min_value, 2) == Ok("-1000000000000000")
  assert to_base(35, 36) == Ok("z")
  assert to_base(max_value, 37) == Err(Nil)
  assert to_base(max_value, 1) == Err(Nil)
}

test "comparing i16 values" {
  assert compare(-1, 1) == Less
  assert compare(3, 3) == Equal
  assert min(-100, 7) == -100
  assert max(-100, 7) == 7
}

test "i16 operators as functions" {
  assert add(100, 27) == 127
  assert sub(-100, 28) == -128
  assert mul(-4, 5) == -20
  assert div(-7, 2) == -3
  assert rem(-7, 2) == -1
  assert neg(127) == -127
  assert abs(-127) == 127
}

test "i16 checked arithmetic reports overflow" {
  assert checked_add(100, 27) == Ok(127)
  assert checked_add(max_value, 1) == Err(Nil)
  assert checked_sub(min_value, 1) == Err(Nil)
  assert checked_mul(max_value, 2) == Err(Nil)
  assert checked_div(min_value, -1) == Err(Nil)
  assert checked_rem(7, 0) == Err(Nil)
  assert checked_neg(min_value) == Err(Nil)
}

test "i16 wrapping arithmetic wraps around" {
  assert wrapping_add(max_value, 1) == min_value
  assert wrapping_sub(min_value, 1) == max_value
  assert wrapping_mul(max_value, 2) == -2
  assert wrapping_neg(min_value) == min_value
}

// Puzzle helpers. They sit at the end of the file, so no std location that
// a golden pins moves (D-1603).

/// Returns the greatest common divisor of `a` and `b`, which is never
/// negative, and `0` for `gcd(0, 0)` (D-1606). It panics only when the
/// result does not fit, as for `gcd(min_value, 0)`.
pub fn gcd(a: I16, b: I16) -> I16 {
  // Euclid's steps on values made non-positive, whose range holds the
  // negation of every `I16`, so only the last `-` can overflow.
  fn step(x: I16, y: I16) -> I16 {
    case y {
      0 => -x
      _ => step(y, x % y)
    }
  }
  step(non_positive(a), non_positive(b))
}

/// `n` with its sign made negative, which always fits.
priv fn non_positive(n: I16) -> I16 {
  case {
    n > 0 => -n
    _ => n
  }
}

/// Returns the least common multiple of `a` and `b`, which is never
/// negative, and `0` when either is `0` (D-1606). It panics when the result
/// does not fit.
pub fn lcm(a: I16, b: I16) -> I16 {
  case a, b {
    0, _ => 0
    _, 0 => 0
    _, _ => abs(a / gcd(a, b) * b)
  }
}

test "i16 gcd and lcm" {
  assert gcd(12, -18) == 6
  assert gcd(0, -5) == 5
  assert gcd(0, 0) == 0
  assert gcd(min_value, 6) == 2
  assert gcd(min_value, -1) == 1
  assert lcm(-4, 6) == 12
  assert lcm(0, 6) == 0
  assert lcm(max_value, 1) == max_value
}
