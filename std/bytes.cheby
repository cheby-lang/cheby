//! `Bytes`, immutable byte sequences for binary data: creating, reading,
//! building, and integers in a named byte order (D-095, D-334).
//!
//! `Bytes` itself is a builtin item whose home module is this one
//! (D-447, D-481), so it is not declared here. As in the
//! spec's signatures, `Bytes` is written unqualified in this module
//! (D-481). It does not satisfy `Show` (D-388).

import std::u32

// Creating

/// Returns an empty `Bytes`.
@external(native, "cheby_bytes_new")
@external(js, "./bytes.mjs", "new")
pub fn new() -> Bytes

test "new is empty" {
  assert length(new()) == 0
  assert new() == from_list([])
}

/// Returns the bytes in `values`, in order.
@external(native, "cheby_bytes_from_list")
@external(js, "./bytes.mjs", "from_list")
pub fn from_list(values: List<U8>) -> Bytes

test "from_list keeps the order" {
  let data = from_list([0xFF, 0x00, 0x7F])
  assert to_list(data) == [0xFF, 0x00, 0x7F]
  assert length(data) == 3
}

/// Returns the UTF-8 encoding of `text`, with no byte-order mark.
@external(native, "cheby_bytes_from_string")
@external(js, "./bytes.mjs", "from_string")
pub fn from_string(text: String) -> Bytes

// Reading

/// Returns the number of bytes in `data` (D-301).
@external(native, "cheby_bytes_length")
@external(js, "./bytes.mjs", "length")
pub fn length(data: Bytes) -> Int

test "length counts bytes" {
  assert length(from_list([1, 2, 3])) == 3
  assert length(new()) == 0
}

/// Tells whether `data` holds no bytes.
pub fn is_empty(data: Bytes) -> Bool {
  length(data) == 0
}

test "is_empty is true only without bytes" {
  assert is_empty(new())
  assert !is_empty(from_list([0]))
}

/// Returns the byte at `index`, or `None` outside `0` to `length - 1` (D-318).
@external(native, "cheby_bytes_get")
@external(js, "./bytes.mjs", "get")
pub fn get(data: Bytes, index: Int) -> Option<U8>

test "get reads one byte" {
  let data = from_list([10, 20, 30])
  assert get(data, 1) == Some(20)
  assert get(data, 3) == None
  assert get(data, -1) == None
}

/// Returns the offset of the first byte at or after `from` that is `"`, `\`
/// or below 0x20, or the length of `data` when there is none. `from` is
/// clamped between 0 and the length of `data`, as `slice` clamps its bounds.
/// Every byte of a multi-byte UTF-8 sequence is at least 0x80, so none of
/// them stops it.
/// `std::json`'s parser finds the plain runs of its strings with it (D-900,
/// D-904).
@external(native, "cheby_bytes_json_plain_end")
@external(js, "./bytes.mjs", "json_plain_end")
@std_clamped(from)
fn json_plain_end(data: Bytes, from: Int) -> Int

test "json_plain_end finds the next quote, backslash or control byte" {
  let data = from_string("ab\"c\\d\u{1}é")
  let negative = -4
  assert json_plain_end(data, 0) == 2
  assert json_plain_end(data, 3) == 4
  assert json_plain_end(data, 5) == 6
  assert json_plain_end(data, 7) == 9
  assert json_plain_end(data, 9) == 9
  assert json_plain_end(data, 99) == 9
  assert json_plain_end(data, negative) == 2
  assert json_plain_end(from_list([0x7F, 0x80, 0xFF, 0x1F]), 0) == 3
  assert json_plain_end(new(), 0) == 0
}

/// Returns the position of the first occurrence of `part` in `data` that
/// starts at or after `from`, or `None`. `from` is where the search starts,
/// so it is clamped between 0 and the length of `data`, as `slice` clamps
/// its bounds, and an empty `part` is found at the clamped `from` (D-298,
/// D-1094).
@external(native, "cheby_bytes_index_of")
@external(js, "./bytes.mjs", "index_of")
@std_clamped(from)
pub fn index_of(data: Bytes, part: Bytes, from: Int) -> Option<Int>

test "index_of finds a part at or after a position" {
  let data = from_string("GET / HTTP/1.1\r\n\r\nbody")
  let blank = from_string("\r\n\r\n")
  assert index_of(data, blank, 0) == Some(14)
  assert index_of(data, from_string(" "), 4) == Some(5)
  assert index_of(data, blank, 15) == None
  assert index_of(data, new(), 3) == Some(3)
}

test "index_of clamps where the search starts" {
  let data = from_list([0x0A, 0x41, 0x0A])
  let line_feed = from_list([0x0A])
  let negative = -3
  assert index_of(data, line_feed, negative) == Some(0)
  assert index_of(data, line_feed, 1) == Some(2)
  assert index_of(data, line_feed, 3) == None
  assert index_of(data, new(), 99) == Some(3)
  assert index_of(new(), new(), 0) == Some(0)
  assert index_of(data, from_list([0x0A, 0x41, 0x0A, 0x41]), 0) == None
}

/// Returns the bytes of `data` from `start` up to but not including `end` (D-319).
@external(native, "cheby_bytes_slice")
@external(js, "./bytes.mjs", "slice")
@std_clamped(start, end)
pub fn slice(data: Bytes, start: Int, end: Int) -> Bytes

test "slice takes a range of bytes" {
  let data = from_list([1, 2, 3, 4])
  let negative = -2
  assert slice(data, 1, 3) == from_list([2, 3])
  assert slice(data, 2, 100) == from_list([3, 4])
  assert slice(data, negative, 1) == from_list([1])
  assert slice(data, 3, 1) == new()
}

/// Returns the bytes of `data` as a list, in order.
@external(native, "cheby_bytes_to_list")
@external(js, "./bytes.mjs", "to_list")
pub fn to_list(data: Bytes) -> List<U8>

test "to_list gives every byte" {
  assert to_list(from_list([0x01, 0xFE])) == [0x01, 0xFE]
  assert to_list(new()) == []
}

/// Calls `f` with the result so far and each byte of `data`, front to back.
pub fn fold<A>(data: Bytes, initial: A, f: fn(A, U8) -> A) -> A {
  fn step(acc, index) {
    case get(data, index) {
      Some(byte) => step(f(acc, byte), index + 1)
      None => acc
    }
  }
  step(initial, 0)
}

test "fold visits bytes front to back" {
  let data = from_list([1, 2, 3])
  let sum: U32 = fold(data, 0, fn(total, byte) { total + u32::from_u8(byte) })
  assert sum == 6
  assert fold(data, [], fn(found, byte) { [byte, ..found] }) == [3, 2, 1]
}

/// Calls `f` with the result so far and each byte of `data`, front to back,
/// stops at the first `Err` and returns it, and otherwise returns `Ok` of the
/// last result (D-1080).
pub fn try_fold<A, E>(data: Bytes, initial: A, f: fn(A, U8) -> Result<A, E>) -> Result<A, E> {
  fn step(acc, index) {
    case get(data, index) {
      Some(byte) => case f(acc, byte) {
        Ok(more) => step(more, index + 1)
        Err(error) => Err(error)
      }
      None => Ok(acc)
    }
  }
  step(initial, 0)
}

test "try_fold stops at the first error" {
  fn small(seen: List<U8>, byte: U8) -> Result<List<U8>, List<U8>> {
    case byte < 0x80 {
      True => Ok([byte, ..seen])
      False => Err([byte, ..seen])
    }
  }
  let data = from_list([1, 2, 0xC3, 3, 0xFF])
  assert try_fold(data, [], small) == Err([0xC3, 2, 1])
  assert try_fold(slice(data, 0, 2), [], small) == Ok([2, 1])
  assert try_fold(new(), [7], small) == Ok([7])
}

// Building

/// Returns `data` with `byte` added at the end, in place when it is not shared (D-316).
@external(native, "cheby_bytes_push")
@external(js, "./bytes.mjs", "push")
pub fn push(data: Bytes, byte: U8) -> Bytes

test "push adds one byte" {
  let data = new()
    |> push(_, 0x41)
    |> push(_, 0x42)
  assert data == from_string("AB")
}

/// Returns the bytes of `data` followed by those of `other` (D-316).
@external(native, "cheby_bytes_append")
@external(js, "./bytes.mjs", "append")
pub fn append(data: Bytes, other: Bytes) -> Bytes

test "append joins two sequences" {
  let head = from_list([1, 2])
  assert append(head, from_list([3])) == from_list([1, 2, 3])
  assert append(head, new()) == head
}

/// Returns the bytes of every element of `parts`, in order.
@external(native, "cheby_bytes_concat")
@external(js, "./bytes.mjs", "concat")
pub fn concat(parts: List<Bytes>) -> Bytes

test "concat joins many sequences" {
  let parts = [from_string("ab"), new(), from_string("c")]
  assert concat(parts) == from_string("abc")
  assert concat([]) == new()
}

// Integers in a byte order (D-334)

/// Returns `data` with `value` added as one byte in two's complement.
@external(native, "cheby_bytes_push_i8")
@external(js, "./bytes.mjs", "push_i8")
pub fn push_i8(data: Bytes, value: I8) -> Bytes

test "push_i8 writes two's complement" {
  assert push_i8(new(), -1) == from_list([0xFF])
  assert push_i8(new(), 5) == from_list([0x05])
}

/// Reads the byte at `offset` as an `I8` in two's complement.
@external(native, "cheby_bytes_read_i8")
@external(js, "./bytes.mjs", "read_i8")
pub fn read_i8(data: Bytes, offset: Int) -> Option<I8>

test "read_i8 reads two's complement" {
  let data = from_list([0xFF, 0x05])
  assert read_i8(data, 0) == Some(-1)
  assert read_i8(data, 1) == Some(5)
  assert read_i8(data, 2) == None
}

/// Returns `data` with `value` added as 2 bytes, big-endian.
@external(native, "cheby_bytes_push_u16_be")
@external(js, "./bytes.mjs", "push_u16_be")
pub fn push_u16_be(data: Bytes, value: U16) -> Bytes

test "16-bit pushes name their byte order" {
  assert push_u16_be(new(), 0x0102) == from_list([0x01, 0x02])
  assert push_u16_le(new(), 0x0102) == from_list([0x02, 0x01])
  assert push_i16_be(new(), -2) == from_list([0xFF, 0xFE])
  assert push_i16_le(new(), -2) == from_list([0xFE, 0xFF])
}

/// Returns `data` with `value` added as 2 bytes, little-endian.
@external(native, "cheby_bytes_push_u16_le")
@external(js, "./bytes.mjs", "push_u16_le")
pub fn push_u16_le(data: Bytes, value: U16) -> Bytes

/// Returns `data` with `value` added as 2 bytes, big-endian.
@external(native, "cheby_bytes_push_i16_be")
@external(js, "./bytes.mjs", "push_i16_be")
pub fn push_i16_be(data: Bytes, value: I16) -> Bytes

/// Returns `data` with `value` added as 2 bytes, little-endian.
@external(native, "cheby_bytes_push_i16_le")
@external(js, "./bytes.mjs", "push_i16_le")
pub fn push_i16_le(data: Bytes, value: I16) -> Bytes

/// Reads the 2 bytes at `offset` as one `U16`, big-endian.
@external(native, "cheby_bytes_read_u16_be")
@external(js, "./bytes.mjs", "read_u16_be")
pub fn read_u16_be(data: Bytes, offset: Int) -> Option<U16>

test "16-bit reads name their byte order" {
  let data = from_list([0x01, 0x02, 0xFF])
  assert read_u16_be(data, 0) == Some(0x0102)
  assert read_u16_le(data, 0) == Some(0x0201)
  assert read_i16_le(data, 1) == Some(-254)
  assert read_i16_be(data, 1) == Some(0x02FF)
  assert read_u16_be(data, 2) == None
  assert read_u16_be(data, -1) == None
}

/// Reads the 2 bytes at `offset` as one `U16`, little-endian.
@external(native, "cheby_bytes_read_u16_le")
@external(js, "./bytes.mjs", "read_u16_le")
pub fn read_u16_le(data: Bytes, offset: Int) -> Option<U16>

/// Reads the 2 bytes at `offset` as one `I16`, big-endian.
@external(native, "cheby_bytes_read_i16_be")
@external(js, "./bytes.mjs", "read_i16_be")
pub fn read_i16_be(data: Bytes, offset: Int) -> Option<I16>

/// Reads the 2 bytes at `offset` as one `I16`, little-endian.
@external(native, "cheby_bytes_read_i16_le")
@external(js, "./bytes.mjs", "read_i16_le")
pub fn read_i16_le(data: Bytes, offset: Int) -> Option<I16>

/// Returns `data` with `value` added as 4 bytes, big-endian.
@external(native, "cheby_bytes_push_u32_be")
@external(js, "./bytes.mjs", "push_u32_be")
pub fn push_u32_be(data: Bytes, value: U32) -> Bytes

test "32-bit pushes name their byte order" {
  assert push_u32_be(new(), 0xCBF4_3926) == from_list([0xCB, 0xF4, 0x39, 0x26])
  assert push_u32_le(new(), 0xCBF4_3926) == from_list([0x26, 0x39, 0xF4, 0xCB])
  assert push_i32_be(new(), -1) == from_list([0xFF, 0xFF, 0xFF, 0xFF])
}

/// Returns `data` with `value` added as 4 bytes, little-endian.
@external(native, "cheby_bytes_push_u32_le")
@external(js, "./bytes.mjs", "push_u32_le")
pub fn push_u32_le(data: Bytes, value: U32) -> Bytes

/// Returns `data` with `value` added as 4 bytes, big-endian.
@external(native, "cheby_bytes_push_i32_be")
@external(js, "./bytes.mjs", "push_i32_be")
pub fn push_i32_be(data: Bytes, value: I32) -> Bytes

/// Returns `data` with `value` added as 4 bytes, little-endian.
@external(native, "cheby_bytes_push_i32_le")
@external(js, "./bytes.mjs", "push_i32_le")
pub fn push_i32_le(data: Bytes, value: I32) -> Bytes

/// Reads the 4 bytes at `offset` as one `U32`, big-endian.
@external(native, "cheby_bytes_read_u32_be")
@external(js, "./bytes.mjs", "read_u32_be")
pub fn read_u32_be(data: Bytes, offset: Int) -> Option<U32>

test "32-bit reads name their byte order" {
  let data = from_list([0x89, 0x50, 0x4E, 0x47])
  assert read_u32_be(data, 0) == Some(0x8950_4E47)
  assert read_u32_le(data, 0) == Some(0x474E_5089)
  assert read_i32_be(data, 0) == Some(-1_991_225_785)
  assert read_u32_be(data, 1) == None
}

/// Reads the 4 bytes at `offset` as one `U32`, little-endian.
@external(native, "cheby_bytes_read_u32_le")
@external(js, "./bytes.mjs", "read_u32_le")
pub fn read_u32_le(data: Bytes, offset: Int) -> Option<U32>

/// Reads the 4 bytes at `offset` as one `I32`, big-endian.
@external(native, "cheby_bytes_read_i32_be")
@external(js, "./bytes.mjs", "read_i32_be")
pub fn read_i32_be(data: Bytes, offset: Int) -> Option<I32>

/// Reads the 4 bytes at `offset` as one `I32`, little-endian.
@external(native, "cheby_bytes_read_i32_le")
@external(js, "./bytes.mjs", "read_i32_le")
pub fn read_i32_le(data: Bytes, offset: Int) -> Option<I32>

/// Returns `data` with `value` added as 8 bytes, big-endian.
@external(native, "cheby_bytes_push_u64_be")
@external(js, "./bytes.mjs", "push_u64_be")
pub fn push_u64_be(data: Bytes, value: U64) -> Bytes

test "64-bit pushes name their byte order" {
  let big = push_u64_be(new(), 0x0102_0304_0506_0708)
  let little = push_u64_le(new(), 0x0102_0304_0506_0708)
  assert to_list(big) == [0x01, 0x02, 0x03, 0x04, 0x05, 0x06, 0x07, 0x08]
  assert to_list(little) == [0x08, 0x07, 0x06, 0x05, 0x04, 0x03, 0x02, 0x01]
  assert push_i64_le(new(), -1) == from_list([0xFF, 0xFF, 0xFF, 0xFF, 0xFF, 0xFF, 0xFF, 0xFF])
}

/// Returns `data` with `value` added as 8 bytes, little-endian.
@external(native, "cheby_bytes_push_u64_le")
@external(js, "./bytes.mjs", "push_u64_le")
pub fn push_u64_le(data: Bytes, value: U64) -> Bytes

/// Returns `data` with `value` added as 8 bytes, big-endian.
@external(native, "cheby_bytes_push_i64_be")
@external(js, "./bytes.mjs", "push_i64_be")
pub fn push_i64_be(data: Bytes, value: I64) -> Bytes

/// Returns `data` with `value` added as 8 bytes, little-endian.
@external(native, "cheby_bytes_push_i64_le")
@external(js, "./bytes.mjs", "push_i64_le")
pub fn push_i64_le(data: Bytes, value: I64) -> Bytes

/// Reads the 8 bytes at `offset` as one `U64`, big-endian.
@external(native, "cheby_bytes_read_u64_be")
@external(js, "./bytes.mjs", "read_u64_be")
pub fn read_u64_be(data: Bytes, offset: Int) -> Option<U64>

test "64-bit reads name their byte order" {
  let data = from_list([0x01, 0x02, 0x03, 0x04, 0x05, 0x06, 0x07, 0x08])
  let all_ones = from_list([0xFF, 0xFF, 0xFF, 0xFF, 0xFF, 0xFF, 0xFF, 0xFF])
  assert read_u64_be(data, 0) == Some(0x0102_0304_0506_0708)
  assert read_u64_le(data, 0) == Some(0x0807_0605_0403_0201)
  assert read_i64_be(all_ones, 0) == Some(-1)
  assert read_u64_le(all_ones, 0) == Some(0xFFFF_FFFF_FFFF_FFFF)
  assert read_u64_be(data, 1) == None
}

/// Reads the 8 bytes at `offset` as one `U64`, little-endian.
@external(native, "cheby_bytes_read_u64_le")
@external(js, "./bytes.mjs", "read_u64_le")
pub fn read_u64_le(data: Bytes, offset: Int) -> Option<U64>

/// Reads the 8 bytes at `offset` as one `I64`, big-endian.
@external(native, "cheby_bytes_read_i64_be")
@external(js, "./bytes.mjs", "read_i64_be")
pub fn read_i64_be(data: Bytes, offset: Int) -> Option<I64>

/// Reads the 8 bytes at `offset` as one `I64`, little-endian.
@external(native, "cheby_bytes_read_i64_le")
@external(js, "./bytes.mjs", "read_i64_le")
pub fn read_i64_le(data: Bytes, offset: Int) -> Option<I64>

// Puzzle helpers. They sit at the end of the file, so no std location that
// a golden pins moves (D-1603).

/// Returns the byte at `index`, or `default` when `index` is outside the
/// bytes (D-1648, D-1659).
pub fn get_or(data: Bytes, index: Int, default: U8) -> U8 {
  case get(data, index) {
    Some(byte) => byte
    None => default
  }
}

test "get_or falls back outside the bytes" {
  let data = from_list([10, 20, 30])
  let negative = -1
  assert get_or(data, 1, 0) == 20
  assert get_or(data, 3, 0) == 0
  assert get_or(data, negative, 255) == 255
  assert get_or(new(), 0, 7) == 7
}

/// Returns the last `count` bytes of `data` (D-1653, D-1659).
@std_clamped(count)
pub fn take_last(data: Bytes, count: Int) -> Bytes {
  case count > 0 {
    True => slice(data, length(data) - count, length(data))
    False => new()
  }
}

test "take_last keeps a suffix" {
  let data = from_list([1, 2, 3])
  let negative = -1
  let huge = 9_007_199_254_740_991
  assert take_last(data, 2) == from_list([2, 3])
  assert take_last(data, 10) == data
  assert take_last(data, 0) == new()
  assert take_last(data, negative) == new()
  assert take_last(data, 0 - huge) == new()
  assert take_last(data, huge) == data
}

/// Returns `data` without its last `count` bytes (D-1653, D-1659).
@std_clamped(count)
pub fn drop_last(data: Bytes, count: Int) -> Bytes {
  case count > 0 {
    True => slice(data, 0, length(data) - count)
    False => data
  }
}

test "drop_last removes a suffix" {
  let data = from_list([1, 2, 3])
  let negative = -1
  let huge = 9_007_199_254_740_991
  assert drop_last(data, 1) == from_list([1, 2])
  assert drop_last(data, 10) == new()
  assert drop_last(data, 0) == data
  assert drop_last(data, negative) == data
  assert drop_last(data, 0 - huge) == data
  assert drop_last(data, huge) == new()
}
