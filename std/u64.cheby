//! The built-in `U64`, a unsigned 64-bit integer: constants, conversions,
//! parsing and text, comparison, and checked and wrapping arithmetic
//! (the integer families of `docs/stdlib/README.md`, D-350).
//!
//! `U64` itself is a builtin item whose home module is this one (D-447).

import std::i64
import std::int
import std::string

// Constants

/// The smallest `U64`.
pub const min_value: U64 = 0

/// The largest `U64`.
pub const max_value: U64 = 18_446_744_073_709_551_615

// Conversions

/// Returns `n` as an `U64`, or `Err(Nil)` when it does not fit.
@external(native, "cheby_u64_from_int")
@external(js, "./u64.mjs", "from_int")
pub fn from_int(n: Int) -> Result<U64, Nil>

/// Returns `n` as an `U64`, or `Err(Nil)` when it does not fit.
@external(native, "cheby_u64_from_i8")
@external(js, "./u64.mjs", "from_i8")
pub fn from_i8(n: I8) -> Result<U64, Nil>

/// Returns `n` as an `U64`, or `Err(Nil)` when it does not fit.
@external(native, "cheby_u64_from_i16")
@external(js, "./u64.mjs", "from_i16")
pub fn from_i16(n: I16) -> Result<U64, Nil>

/// Returns `n` as an `U64`, or `Err(Nil)` when it does not fit.
@external(native, "cheby_u64_from_i32")
@external(js, "./u64.mjs", "from_i32")
pub fn from_i32(n: I32) -> Result<U64, Nil>

/// Returns `n` as an `U64`, or `Err(Nil)` when it does not fit.
@external(native, "cheby_u64_from_i64")
@external(js, "./u64.mjs", "from_i64")
pub fn from_i64(n: I64) -> Result<U64, Nil>

/// Returns `n` as an `U64`. Every `U8` fits.
@external(native, "cheby_u64_from_u8")
@external(js, "./u64.mjs", "from_u8")
pub fn from_u8(n: U8) -> U64

/// Returns `n` as an `U64`. Every `U16` fits.
@external(native, "cheby_u64_from_u16")
@external(js, "./u64.mjs", "from_u16")
pub fn from_u16(n: U16) -> U64

/// Returns `n` as an `U64`. Every `U32` fits.
@external(native, "cheby_u64_from_u32")
@external(js, "./u64.mjs", "from_u32")
pub fn from_u32(n: U32) -> U64

/// Keeps the low 64 bits of `n`'s two's-complement value and reads them as a `U64` (D-1091).
pub fn wrapping_from_int(n: Int) -> U64 {
  case n >= 0 {
    True => {
      let assert Ok(value) = from_int(n)
      value
    }
    False => {
      // `-(n + 1)` fits, and `max_value` minus it is 2^64 + n.
      let assert Ok(complement) = from_int(-(n + 1))
      max_value - complement
    }
  }
}

/// Keeps the low 64 bits of `n`'s two's-complement value and reads them as a `U64` (D-1091).
pub fn wrapping_from_i8(n: I8) -> U64 {
  case n >= 0 {
    True => {
      let assert Ok(value) = from_i8(n)
      value
    }
    False => {
      // `-(n + 1)` fits, and `max_value` minus it is 2^64 + n.
      let assert Ok(complement) = from_i8(-(n + 1))
      max_value - complement
    }
  }
}

/// Keeps the low 64 bits of `n`'s two's-complement value and reads them as a `U64` (D-1091).
pub fn wrapping_from_i16(n: I16) -> U64 {
  case n >= 0 {
    True => {
      let assert Ok(value) = from_i16(n)
      value
    }
    False => {
      // `-(n + 1)` fits, and `max_value` minus it is 2^64 + n.
      let assert Ok(complement) = from_i16(-(n + 1))
      max_value - complement
    }
  }
}

/// Keeps the low 64 bits of `n`'s two's-complement value and reads them as a `U64` (D-1091).
pub fn wrapping_from_i32(n: I32) -> U64 {
  case n >= 0 {
    True => {
      let assert Ok(value) = from_i32(n)
      value
    }
    False => {
      // `-(n + 1)` fits, and `max_value` minus it is 2^64 + n.
      let assert Ok(complement) = from_i32(-(n + 1))
      max_value - complement
    }
  }
}

/// Keeps the low 64 bits of `n`'s two's-complement value and reads them as a `U64` (D-1091).
pub fn wrapping_from_i64(n: I64) -> U64 {
  case n >= 0 {
    True => {
      let assert Ok(value) = from_i64(n)
      value
    }
    False => {
      // `-(n + 1)` fits, and `max_value` minus it is 2^64 + n.
      let assert Ok(complement) = from_i64(-(n + 1))
      max_value - complement
    }
  }
}

test "wrapping_from keeps the low 64 bits of every source" {
  assert wrapping_from_int(-1) == 18_446_744_073_709_551_615
  assert wrapping_from_int(0) == 0
  assert wrapping_from_int(1) == 1
  assert wrapping_from_i8(-128) == 18_446_744_073_709_551_488
  assert wrapping_from_i8(-17) == 18_446_744_073_709_551_599
  assert wrapping_from_i8(-1) == 18_446_744_073_709_551_615
  assert wrapping_from_i8(0) == 0
  assert wrapping_from_i8(1) == 1
  assert wrapping_from_i8(17) == 17
  assert wrapping_from_i8(127) == 127
  assert wrapping_from_i16(-32_768) == 18_446_744_073_709_518_848
  assert wrapping_from_i16(-12_817) == 18_446_744_073_709_538_799
  assert wrapping_from_i16(-1) == 18_446_744_073_709_551_615
  assert wrapping_from_i16(0) == 0
  assert wrapping_from_i16(1) == 1
  assert wrapping_from_i16(12_817) == 12_817
  assert wrapping_from_i16(32_767) == 32_767
  assert wrapping_from_i32(-2_147_483_648) == 18_446_744_071_562_067_968
  assert wrapping_from_i32(-1_985_229_329) == 18_446_744_071_724_322_287
  assert wrapping_from_i32(-1) == 18_446_744_073_709_551_615
  assert wrapping_from_i32(0) == 0
  assert wrapping_from_i32(1) == 1
  assert wrapping_from_i32(1_985_229_329) == 1_985_229_329
  assert wrapping_from_i32(2_147_483_647) == 2_147_483_647
  assert wrapping_from_i64(-9_223_372_036_854_775_808) == 9_223_372_036_854_775_808
  assert wrapping_from_i64(-81_985_529_216_486_895) == 18_364_758_544_493_064_721
  assert wrapping_from_i64(-1) == 18_446_744_073_709_551_615
  assert wrapping_from_i64(0) == 0
  assert wrapping_from_i64(1) == 1
  assert wrapping_from_i64(81_985_529_216_486_895) == 81_985_529_216_486_895
  assert wrapping_from_i64(9_223_372_036_854_775_807) == 9_223_372_036_854_775_807
}

@target(native)
test "wrapping_from_int keeps the low 64 bits of every Int" {
  assert wrapping_from_int(-9_223_372_036_854_775_808) == 9_223_372_036_854_775_808
  assert wrapping_from_int(-81_985_529_216_486_895) == 18_364_758_544_493_064_721
  assert wrapping_from_int(81_985_529_216_486_895) == 81_985_529_216_486_895
  assert wrapping_from_int(9_223_372_036_854_775_807) == 9_223_372_036_854_775_807
}

// Parsing and text

/// Reads an `U64` written as an optional `-` and ASCII decimal digits (D-312).
@external(native, "cheby_u64_parse")
@external(js, "./u64.mjs", "parse")
pub fn parse(text: String) -> Result<U64, Nil>

/// Reads an `U64` written in `base`, from 2 to 36, as an optional `-` and digits.
@external(native, "cheby_u64_parse_base")
@external(js, "./u64.mjs", "parse_base")
pub fn parse_base(text: String, base: Int) -> Result<U64, Nil>

/// Returns `n` written in `base`, from 2 to 36, in lowercase digits (D-390, D-1090).
pub fn to_base(n: U64, base: Int) -> Result<String, Nil> {
  case base >= 2 && base <= 36 {
    False => Err(Nil)
    True => {
      let assert Ok(wide) = from_int(base)
      Ok(base_digits(n, wide, base, ""))
    }
  }
}

/// The digits of `n` in `base`, in front of `after`. Each digit is below
/// 36, so it fits `Int` on every target, where `n` may not.
fn base_digits(n: U64, wide: U64, base: Int, after: String) -> String {
  let assert Ok(digit) = int::from_u64(n % wide)
  let assert Ok(text) = int::to_base(digit, base)
  case n / wide {
    0 => "{text}{after}"
    rest => base_digits(rest, wide, base, "{text}{after}")
  }
}

test "to_base writes every U64 in every base" {
  assert to_base(0, 2) == Ok("0")
  assert to_base(0, 8) == Ok("0")
  assert to_base(0, 10) == Ok("0")
  assert to_base(0, 16) == Ok("0")
  assert to_base(0, 36) == Ok("0")
  assert to_base(1, 2) == Ok("1")
  assert to_base(1, 8) == Ok("1")
  assert to_base(1, 10) == Ok("1")
  assert to_base(1, 16) == Ok("1")
  assert to_base(1, 36) == Ok("1")
  assert to_base(81_985_529_216_486_895, 2) ==
    Ok("100100011010001010110011110001001101010111100110111101111")
  assert to_base(81_985_529_216_486_895, 8) == Ok("4432126361152746757")
  assert to_base(81_985_529_216_486_895, 10) == Ok("81985529216486895")
  assert to_base(81_985_529_216_486_895, 16) == Ok("123456789abcdef")
  assert to_base(81_985_529_216_486_895, 36) == Ok("mf9g063v08f")
  assert to_base(18_446_744_073_709_551_615, 2) ==
    Ok("1111111111111111111111111111111111111111111111111111111111111111")
  assert to_base(18_446_744_073_709_551_615, 8) == Ok("1777777777777777777777")
  assert to_base(18_446_744_073_709_551_615, 10) == Ok("18446744073709551615")
  assert to_base(18_446_744_073_709_551_615, 16) == Ok("ffffffffffffffff")
  assert to_base(18_446_744_073_709_551_615, 36) == Ok("3w5e11264sgsf")
  assert to_base(max_value, 0) == Err(Nil)
  assert to_base(max_value, -16) == Err(Nil)
  assert to_base(min_value, 37) == Err(Nil)
  fn round_trips(n: U64, base: Int) -> Bool {
    case base > 36 {
      True => True
      False => {
        let assert Ok(text) = to_base(n, base)
        parse_base(text, base) == Ok(n) && round_trips(n, base + 1)
      }
    }
  }
  assert round_trips(0, 2)
  assert round_trips(1, 2)
  assert round_trips(18_446_744_073_709_551_615, 2)
}

/// Returns `n` in decimal. It makes `U64` satisfy `Show`.
@external(native, "cheby_u64_show")
@external(js, "./u64.mjs", "show")
pub fn show(n: U64) -> String

// Comparison

/// Orders two `U64` values. It makes `U64` satisfy `Compare`.
pub fn compare(a: U64, b: U64) -> Order {
  case {
    a < b => Less
    a > b => Greater
    _ => Equal
  }
}

/// Returns the smaller of `a` and `b`, and `a` when they are `Equal`.
pub fn min(a: U64, b: U64) -> U64 {
  case {
    b < a => b
    _ => a
  }
}

/// Returns the larger of `a` and `b`, and `a` when they are `Equal`.
pub fn max(a: U64, b: U64) -> U64 {
  case {
    b > a => b
    _ => a
  }
}

// Arithmetic

/// Returns `a + b`, and panics when the result does not fit. It makes `U64` satisfy `Add`.
pub fn add(a: U64, b: U64) -> U64 {
  a + b
}

/// Returns `a - b`, and panics when the result does not fit. It makes `U64` satisfy `Sub`.
pub fn sub(a: U64, b: U64) -> U64 {
  a - b
}

/// Returns `a * b`, and panics when the result does not fit. It makes `U64` satisfy `Mul`.
pub fn mul(a: U64, b: U64) -> U64 {
  a * b
}

/// Returns `a / b` toward zero, panicking like `/`. It makes `U64` satisfy `Div`.
pub fn div(a: U64, b: U64) -> U64 {
  a / b
}

/// Returns `a % b`, with the sign of `a`, and panics on a zero divisor.
pub fn rem(a: U64, b: U64) -> U64 {
  a % b
}

/// Returns `-n`, and panics when it does not fit. It makes `U64` satisfy `Neg`.
pub fn neg(n: U64) -> U64 {
  -n
}

/// Returns `n`, since `U64` has no negative values.
pub fn abs(n: U64) -> U64 {
  n
}

// Checked arithmetic

/// Returns `Ok(a + b)`, or `Err(Nil)` when the sum does not fit (D-309).
@external(native, "cheby_u64_checked_add")
@external(js, "./u64.mjs", "checked_add")
pub fn checked_add(a: U64, b: U64) -> Result<U64, Nil>

/// Returns `Ok(a - b)`, or `Err(Nil)` when the difference does not fit (D-309).
@external(native, "cheby_u64_checked_sub")
@external(js, "./u64.mjs", "checked_sub")
pub fn checked_sub(a: U64, b: U64) -> Result<U64, Nil>

/// Returns `Ok(a * b)`, or `Err(Nil)` when the product does not fit (D-309).
@external(native, "cheby_u64_checked_mul")
@external(js, "./u64.mjs", "checked_mul")
pub fn checked_mul(a: U64, b: U64) -> Result<U64, Nil>

/// Returns `Ok(a / b)`, or `Err(Nil)` for a zero divisor (D-356).
pub fn checked_div(a: U64, b: U64) -> Result<U64, Nil> {
  case b {
    0 => Err(Nil)
    _ => Ok(a / b)
  }
}

/// Returns `Ok(a % b)`, or `Err(Nil)` for a zero divisor (D-356).
pub fn checked_rem(a: U64, b: U64) -> Result<U64, Nil> {
  case b {
    0 => Err(Nil)
    _ => Ok(a % b)
  }
}

/// Returns `Ok(n)` for 0, the only value whose negation fits, and `Err(Nil)` otherwise (D-309).
pub fn checked_neg(n: U64) -> Result<U64, Nil> {
  case n {
    0 => Ok(n)
    _ => Err(Nil)
  }
}

// Wrapping arithmetic

/// Returns `a + b` modulo 2^64 (D-025).
@external(native, "cheby_u64_wrapping_add")
@external(js, "./u64.mjs", "wrapping_add")
pub fn wrapping_add(a: U64, b: U64) -> U64

/// Returns `a - b` modulo 2^64 (D-025).
@external(native, "cheby_u64_wrapping_sub")
@external(js, "./u64.mjs", "wrapping_sub")
pub fn wrapping_sub(a: U64, b: U64) -> U64

/// Returns `a * b` modulo 2^64 (D-025).
@external(native, "cheby_u64_wrapping_mul")
@external(js, "./u64.mjs", "wrapping_mul")
pub fn wrapping_mul(a: U64, b: U64) -> U64

/// Returns `-n` modulo 2^64 (D-025).
@external(native, "cheby_u64_wrapping_neg")
@external(js, "./u64.mjs", "wrapping_neg")
pub fn wrapping_neg(n: U64) -> U64

// Tests of `std::i64` that need this module.

test "conversions to i64" {
  assert i64::from_int(-42) == -42
  assert i64::from_u32(4_294_967_295) == 4_294_967_295
  assert i64::from_u64(42) == Ok(42)
  assert i64::from_u64(max_value) == Err(Nil)
  assert int::from_i64(i64::from_int(-42)) == Ok(-42)
  assert i64::wrapping_from_u64(0x0123_4567_89AB_CDEF) == 0x0123_4567_89AB_CDEF
  assert i64::wrapping_from_u64(18_446_744_073_709_551_615) == -1
  assert i64::wrapping_from_u64(9_223_372_036_854_775_808) == i64::min_value
}

// Tests of `std::int` that need this module.

test "from_u64 fails above Int's range" {
  assert int::from_u64(42) == Ok(42)
  assert int::from_u64(max_value) == Err(Nil)
}

// Examples

test "the u64 range" {
  assert min_value == 0
  assert max_value == 18_446_744_073_709_551_615
}

test "conversions to u64" {
  assert from_u32(4_294_967_295) == 4_294_967_295
  assert from_int(42) == Ok(42)
  assert from_int(-1) == Err(Nil)
  assert from_i64(i64::max_value) == Ok(9_223_372_036_854_775_807)
  assert wrapping_from_int(-1) == max_value
  assert wrapping_from_i8(-1) == max_value
  assert wrapping_from_i64(i64::min_value) == 9_223_372_036_854_775_808
  assert wrapping_from_int(200) == 200
}

test "u64 parses and shows decimal digits" {
  let small: U64 = 7
  assert parse("18446744073709551615") == Ok(max_value)
  assert parse("18446744073709551616") == Err(Nil)
  assert parse_base("ffffffffffffffff", 16) == Ok(max_value)
  assert show(max_value) == "18446744073709551615"
  assert "{small}" == "7"
  assert to_base(max_value, 16) == Ok("ffffffffffffffff")
  assert to_base(min_value, 2) == Ok("0")
  assert to_base(35, 36) == Ok("z")
  assert to_base(max_value, 37) == Err(Nil)
  assert to_base(max_value, 1) == Err(Nil)
}

test "comparing u64 values" {
  assert compare(1, 2) == Less
  assert compare(3, 3) == Equal
  assert min(100, 7) == 7
  assert max(100, 7) == 100
}

test "u64 operators as functions" {
  assert add(200, 55) == 255
  assert sub(7, 2) == 5
  assert mul(15, 17) == 255
  assert div(7, 2) == 3
  assert rem(7, 2) == 1
  assert neg(0) == 0
  assert abs(7) == 7
}

test "u64 checked arithmetic reports overflow" {
  assert checked_add(200, 55) == Ok(255)
  assert checked_add(max_value, 1) == Err(Nil)
  assert checked_sub(0, 1) == Err(Nil)
  assert checked_mul(max_value, 2) == Err(Nil)
  assert checked_div(7, 0) == Err(Nil)
  assert checked_rem(7, 2) == Ok(1)
  assert checked_neg(0) == Ok(0)
  assert checked_neg(1) == Err(Nil)
}

test "u64 wrapping arithmetic wraps around" {
  assert wrapping_add(max_value, 1) == 0
  assert wrapping_sub(0, 1) == max_value
  assert wrapping_mul(max_value, 2) == max_value - 1
  assert wrapping_neg(1) == max_value
}

// Puzzle helpers. They sit at the end of the file, so no std location that
// a golden pins moves (D-1603).

/// Returns the greatest common divisor of `a` and `b`, and `0` for
/// `gcd(0, 0)` (D-1606).
pub fn gcd(a: U64, b: U64) -> U64 {
  case b {
    0 => a
    _ => gcd(b, a % b)
  }
}

/// Returns the least common multiple of `a` and `b`, and `0` when either
/// is `0` (D-1606). It panics when the result does not fit.
pub fn lcm(a: U64, b: U64) -> U64 {
  case a, b {
    0, _ => 0
    _, 0 => 0
    _, _ => a / gcd(a, b) * b
  }
}

test "u64 gcd and lcm" {
  assert gcd(12, 18) == 6
  assert gcd(0, 5) == 5
  assert gcd(0, 0) == 0
  assert gcd(max_value, 5) == 5
  assert lcm(4, 6) == 12
  assert lcm(0, 6) == 0
  assert lcm(max_value, 1) == max_value
}
