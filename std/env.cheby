//! The program's command-line arguments, environment variables and
//! working directory.
//!
//! Tier 1 only reads the environment. Text that is not valid UTF-8 has
//! each invalid sequence replaced with U+FFFD (D-311), except in
//! `current_dir`, which fails instead (D-1440).

import std::io

/// Returns the command-line arguments, in order, without the program name (D-347).
@external(native, "cheby_env_args")
@external(js, "./env.mjs", "args")
pub fn args() -> List<String>

/// Returns the name the program was started with (D-347, D-369).
@external(native, "cheby_env_program_name")
@external(js, "./env.mjs", "program_name")
pub fn program_name() -> String

/// Returns the value of the environment variable `name`, or `None` (D-347, D-370).
@external(native, "cheby_env_get")
@external(js, "./env.mjs", "get")
pub fn get(name: String) -> Option<String>

test "a name that cannot be set gives None" {
  assert get("") == None
  assert get("A=B") == None
}

/// Returns the working directory in the host's own form, such as
/// `C:\Users\me` or `/home/me` (D-1440).
pub fn current_dir() -> Result<String, io::Error> {
  io::lift(sys_current_dir())
}

test "current_dir reads the working directory" {
  let assert Ok(dir) = current_dir()
  assert dir != ""
}

// Kernels

/// Reads the working directory, or the failure's kind and message.
@external(native, "cheby_env_sys_current_dir")
@external(js, "./env.mjs", "sys_current_dir")
priv fn sys_current_dir() -> Result<String, (Int, String)>
