//! The built-in `U32`, a unsigned 32-bit integer: constants, conversions,
//! parsing and text, comparison, and checked and wrapping arithmetic
//! (the integer families of `docs/stdlib/README.md`, D-350).
//!
//! `U32` itself is a builtin item whose home module is this one (D-447).

import std::int

// Constants

/// The smallest `U32`.
pub const min_value: U32 = 0

/// The largest `U32`.
pub const max_value: U32 = 4_294_967_295

// Conversions

/// Returns `n` as an `U32`, or `Err(Nil)` when it does not fit.
@external(native, "cheby_u32_from_int")
@external(js, "./u32.mjs", "from_int")
pub fn from_int(n: Int) -> Result<U32, Nil>

/// Returns `n` as an `U32`, or `Err(Nil)` when it does not fit.
@external(native, "cheby_u32_from_i8")
@external(js, "./u32.mjs", "from_i8")
pub fn from_i8(n: I8) -> Result<U32, Nil>

/// Returns `n` as an `U32`, or `Err(Nil)` when it does not fit.
@external(native, "cheby_u32_from_i16")
@external(js, "./u32.mjs", "from_i16")
pub fn from_i16(n: I16) -> Result<U32, Nil>

/// Returns `n` as an `U32`, or `Err(Nil)` when it does not fit.
@external(native, "cheby_u32_from_i32")
@external(js, "./u32.mjs", "from_i32")
pub fn from_i32(n: I32) -> Result<U32, Nil>

/// Returns `n` as an `U32`, or `Err(Nil)` when it does not fit.
@external(native, "cheby_u32_from_i64")
@external(js, "./u32.mjs", "from_i64")
pub fn from_i64(n: I64) -> Result<U32, Nil>

/// Returns `n` as an `U32`. Every `U8` fits.
@external(native, "cheby_u32_from_u8")
@external(js, "./u32.mjs", "from_u8")
pub fn from_u8(n: U8) -> U32

/// Returns `n` as an `U32`. Every `U16` fits.
@external(native, "cheby_u32_from_u16")
@external(js, "./u32.mjs", "from_u16")
pub fn from_u16(n: U16) -> U32

/// Returns `n` as an `U32`, or `Err(Nil)` when it does not fit.
@external(native, "cheby_u32_from_u64")
@external(js, "./u32.mjs", "from_u64")
pub fn from_u64(n: U64) -> Result<U32, Nil>

/// Keeps the low 32 bits of `n`'s two's-complement value and reads them as a `U32` (D-1091).
pub fn wrapping_from_int(n: Int) -> U32 {
  let assert Ok(low) = from_int(n & 0xFFFF_FFFF)
  low
}

/// Keeps the low 32 bits of `n`'s two's-complement value and reads them as a `U32` (D-1091).
pub fn wrapping_from_i8(n: I8) -> U32 {
  case n >= 0 {
    True => {
      let assert Ok(value) = from_i8(n)
      value
    }
    False => {
      // `-(n + 1)` fits, and `max_value` minus it is 2^32 + n.
      let assert Ok(complement) = from_i8(-(n + 1))
      max_value - complement
    }
  }
}

/// Keeps the low 32 bits of `n`'s two's-complement value and reads them as a `U32` (D-1091).
pub fn wrapping_from_i16(n: I16) -> U32 {
  case n >= 0 {
    True => {
      let assert Ok(value) = from_i16(n)
      value
    }
    False => {
      // `-(n + 1)` fits, and `max_value` minus it is 2^32 + n.
      let assert Ok(complement) = from_i16(-(n + 1))
      max_value - complement
    }
  }
}

/// Keeps the low 32 bits of `n`'s two's-complement value and reads them as a `U32` (D-1091).
pub fn wrapping_from_i32(n: I32) -> U32 {
  case n >= 0 {
    True => {
      let assert Ok(value) = from_i32(n)
      value
    }
    False => {
      // `-(n + 1)` fits, and `max_value` minus it is 2^32 + n.
      let assert Ok(complement) = from_i32(-(n + 1))
      max_value - complement
    }
  }
}

/// Keeps the low 32 bits of `n`'s two's-complement value and reads them as a `U32` (D-1091).
pub fn wrapping_from_i64(n: I64) -> U32 {
  let assert Ok(low) = from_i64(n & 0xFFFF_FFFF)
  low
}

/// Keeps the low 32 bits of `n`'s two's-complement value and reads them as a `U32` (D-1091).
pub fn wrapping_from_u64(n: U64) -> U32 {
  let assert Ok(low) = from_u64(n & 0xFFFF_FFFF)
  low
}

test "wrapping_from keeps the low 32 bits of every source" {
  assert wrapping_from_int(-1) == 4_294_967_295
  assert wrapping_from_int(0) == 0
  assert wrapping_from_int(1) == 1
  assert wrapping_from_int(4_294_967_295) == 4_294_967_295
  assert wrapping_from_int(4_294_967_296) == 0
  assert wrapping_from_i8(-128) == 4_294_967_168
  assert wrapping_from_i8(-17) == 4_294_967_279
  assert wrapping_from_i8(-1) == 4_294_967_295
  assert wrapping_from_i8(0) == 0
  assert wrapping_from_i8(1) == 1
  assert wrapping_from_i8(17) == 17
  assert wrapping_from_i8(127) == 127
  assert wrapping_from_i16(-32_768) == 4_294_934_528
  assert wrapping_from_i16(-12_817) == 4_294_954_479
  assert wrapping_from_i16(-1) == 4_294_967_295
  assert wrapping_from_i16(0) == 0
  assert wrapping_from_i16(1) == 1
  assert wrapping_from_i16(12_817) == 12_817
  assert wrapping_from_i16(32_767) == 32_767
  assert wrapping_from_i32(-2_147_483_648) == 2_147_483_648
  assert wrapping_from_i32(-1_985_229_329) == 2_309_737_967
  assert wrapping_from_i32(-1) == 4_294_967_295
  assert wrapping_from_i32(0) == 0
  assert wrapping_from_i32(1) == 1
  assert wrapping_from_i32(1_985_229_329) == 1_985_229_329
  assert wrapping_from_i32(2_147_483_647) == 2_147_483_647
  assert wrapping_from_i64(-9_223_372_036_854_775_808) == 0
  assert wrapping_from_i64(-81_985_529_216_486_895) == 1_985_229_329
  assert wrapping_from_i64(-1) == 4_294_967_295
  assert wrapping_from_i64(0) == 0
  assert wrapping_from_i64(1) == 1
  assert wrapping_from_i64(4_294_967_295) == 4_294_967_295
  assert wrapping_from_i64(4_294_967_296) == 0
  assert wrapping_from_i64(81_985_529_216_486_895) == 2_309_737_967
  assert wrapping_from_i64(9_223_372_036_854_775_807) == 4_294_967_295
  assert wrapping_from_u64(0) == 0
  assert wrapping_from_u64(1) == 1
  assert wrapping_from_u64(4_294_967_295) == 4_294_967_295
  assert wrapping_from_u64(4_294_967_296) == 0
  assert wrapping_from_u64(81_985_529_216_486_895) == 2_309_737_967
  assert wrapping_from_u64(18_446_744_073_709_551_615) == 4_294_967_295
}

@target(native)
test "wrapping_from_int keeps the low 32 bits of every Int" {
  assert wrapping_from_int(-9_223_372_036_854_775_808) == 0
  assert wrapping_from_int(-81_985_529_216_486_895) == 1_985_229_329
  assert wrapping_from_int(81_985_529_216_486_895) == 2_309_737_967
  assert wrapping_from_int(9_223_372_036_854_775_807) == 4_294_967_295
}

// Parsing and text

/// Reads an `U32` written as an optional `-` and ASCII decimal digits (D-312).
@external(native, "cheby_u32_parse")
@external(js, "./u32.mjs", "parse")
pub fn parse(text: String) -> Result<U32, Nil>

/// Reads an `U32` written in `base`, from 2 to 36, as an optional `-` and digits.
@external(native, "cheby_u32_parse_base")
@external(js, "./u32.mjs", "parse_base")
pub fn parse_base(text: String, base: Int) -> Result<U32, Nil>

/// Returns `n` written in `base`, from 2 to 36, in lowercase digits (D-390, D-1090).
pub fn to_base(n: U32, base: Int) -> Result<String, Nil> {
  int::to_base(int::from_u32(n), base)
}

test "to_base writes every U32 in every base" {
  assert to_base(0, 2) == Ok("0")
  assert to_base(0, 8) == Ok("0")
  assert to_base(0, 10) == Ok("0")
  assert to_base(0, 16) == Ok("0")
  assert to_base(0, 36) == Ok("0")
  assert to_base(1, 2) == Ok("1")
  assert to_base(1, 8) == Ok("1")
  assert to_base(1, 10) == Ok("1")
  assert to_base(1, 16) == Ok("1")
  assert to_base(1, 36) == Ok("1")
  assert to_base(2_309_737_967, 2) == Ok("10001001101010111100110111101111")
  assert to_base(2_309_737_967, 8) == Ok("21152746757")
  assert to_base(2_309_737_967, 10) == Ok("2309737967")
  assert to_base(2_309_737_967, 16) == Ok("89abcdef")
  assert to_base(2_309_737_967, 36) == Ok("1275p7z")
  assert to_base(4_294_967_295, 2) == Ok("11111111111111111111111111111111")
  assert to_base(4_294_967_295, 8) == Ok("37777777777")
  assert to_base(4_294_967_295, 10) == Ok("4294967295")
  assert to_base(4_294_967_295, 16) == Ok("ffffffff")
  assert to_base(4_294_967_295, 36) == Ok("1z141z3")
  assert to_base(max_value, 0) == Err(Nil)
  assert to_base(max_value, -16) == Err(Nil)
  assert to_base(min_value, 37) == Err(Nil)
}

/// Returns `n` in decimal. It makes `U32` satisfy `Show`.
@external(native, "cheby_u32_show")
@external(js, "./u32.mjs", "show")
pub fn show(n: U32) -> String

// Comparison

/// Orders two `U32` values. It makes `U32` satisfy `Compare`.
pub fn compare(a: U32, b: U32) -> Order {
  case {
    a < b => Less
    a > b => Greater
    _ => Equal
  }
}

/// Returns the smaller of `a` and `b`, and `a` when they are `Equal`.
pub fn min(a: U32, b: U32) -> U32 {
  case {
    b < a => b
    _ => a
  }
}

/// Returns the larger of `a` and `b`, and `a` when they are `Equal`.
pub fn max(a: U32, b: U32) -> U32 {
  case {
    b > a => b
    _ => a
  }
}

// Arithmetic

/// Returns `a + b`, and panics when the result does not fit. It makes `U32` satisfy `Add`.
pub fn add(a: U32, b: U32) -> U32 {
  a + b
}

/// Returns `a - b`, and panics when the result does not fit. It makes `U32` satisfy `Sub`.
pub fn sub(a: U32, b: U32) -> U32 {
  a - b
}

/// Returns `a * b`, and panics when the result does not fit. It makes `U32` satisfy `Mul`.
pub fn mul(a: U32, b: U32) -> U32 {
  a * b
}

/// Returns `a / b` toward zero, panicking like `/`. It makes `U32` satisfy `Div`.
pub fn div(a: U32, b: U32) -> U32 {
  a / b
}

/// Returns `a % b`, with the sign of `a`, and panics on a zero divisor.
pub fn rem(a: U32, b: U32) -> U32 {
  a % b
}

/// Returns `-n`, and panics when it does not fit. It makes `U32` satisfy `Neg`.
pub fn neg(n: U32) -> U32 {
  -n
}

/// Returns `n`, since `U32` has no negative values.
pub fn abs(n: U32) -> U32 {
  n
}

// Checked arithmetic

/// Returns `Ok(a + b)`, or `Err(Nil)` when the sum does not fit (D-309).
@external(native, "cheby_u32_checked_add")
@external(js, "./u32.mjs", "checked_add")
pub fn checked_add(a: U32, b: U32) -> Result<U32, Nil>

/// Returns `Ok(a - b)`, or `Err(Nil)` when the difference does not fit (D-309).
@external(native, "cheby_u32_checked_sub")
@external(js, "./u32.mjs", "checked_sub")
pub fn checked_sub(a: U32, b: U32) -> Result<U32, Nil>

/// Returns `Ok(a * b)`, or `Err(Nil)` when the product does not fit (D-309).
@external(native, "cheby_u32_checked_mul")
@external(js, "./u32.mjs", "checked_mul")
pub fn checked_mul(a: U32, b: U32) -> Result<U32, Nil>

/// Returns `Ok(a / b)`, or `Err(Nil)` for a zero divisor (D-356).
pub fn checked_div(a: U32, b: U32) -> Result<U32, Nil> {
  case b {
    0 => Err(Nil)
    _ => Ok(a / b)
  }
}

/// Returns `Ok(a % b)`, or `Err(Nil)` for a zero divisor (D-356).
pub fn checked_rem(a: U32, b: U32) -> Result<U32, Nil> {
  case b {
    0 => Err(Nil)
    _ => Ok(a % b)
  }
}

/// Returns `Ok(n)` for 0, the only value whose negation fits, and `Err(Nil)` otherwise (D-309).
pub fn checked_neg(n: U32) -> Result<U32, Nil> {
  case n {
    0 => Ok(n)
    _ => Err(Nil)
  }
}

// Wrapping arithmetic

/// Returns `a + b` modulo 2^32 (D-025).
@external(native, "cheby_u32_wrapping_add")
@external(js, "./u32.mjs", "wrapping_add")
pub fn wrapping_add(a: U32, b: U32) -> U32

/// Returns `a - b` modulo 2^32 (D-025).
@external(native, "cheby_u32_wrapping_sub")
@external(js, "./u32.mjs", "wrapping_sub")
pub fn wrapping_sub(a: U32, b: U32) -> U32

/// Returns `a * b` modulo 2^32 (D-025).
@external(native, "cheby_u32_wrapping_mul")
@external(js, "./u32.mjs", "wrapping_mul")
pub fn wrapping_mul(a: U32, b: U32) -> U32

/// Returns `-n` modulo 2^32 (D-025).
@external(native, "cheby_u32_wrapping_neg")
@external(js, "./u32.mjs", "wrapping_neg")
pub fn wrapping_neg(n: U32) -> U32

// Examples

test "the u32 range" {
  assert min_value == 0
  assert max_value == 4_294_967_295
}

test "conversions to u32" {
  assert from_u8(255) == 255
  assert from_u16(65_535) == 65_535
  assert from_int(4_294_967_295) == Ok(4_294_967_295)
  assert from_int(-1) == Err(Nil)
  assert from_u64(4_294_967_296) == Err(Nil)
  assert wrapping_from_u64(0x0123_4567_89AB_CDEF) == 0x89AB_CDEF
  assert wrapping_from_int(-1) == max_value
  assert wrapping_from_i32(-2_147_483_648) == 2_147_483_648
  assert wrapping_from_int(200) == 200
}

test "u32 parses and shows decimal digits" {
  let small: U32 = 7
  assert parse("4294967295") == Ok(4_294_967_295)
  assert parse("-1") == Err(Nil)
  assert parse_base("ffffffff", 16) == Ok(max_value)
  assert show(max_value) == "4294967295"
  assert "{small}" == "7"
  assert to_base(max_value, 16) == Ok("ffffffff")
  assert to_base(min_value, 2) == Ok("0")
  assert to_base(35, 36) == Ok("z")
  assert to_base(max_value, 37) == Err(Nil)
  assert to_base(max_value, 1) == Err(Nil)
}

test "comparing u32 values" {
  assert compare(1, 2) == Less
  assert compare(3, 3) == Equal
  assert min(100, 7) == 7
  assert max(100, 7) == 100
}

test "u32 operators as functions" {
  assert add(200, 55) == 255
  assert sub(7, 2) == 5
  assert mul(15, 17) == 255
  assert div(7, 2) == 3
  assert rem(7, 2) == 1
  assert neg(0) == 0
  assert abs(7) == 7
}

test "u32 checked arithmetic reports overflow" {
  assert checked_add(200, 55) == Ok(255)
  assert checked_add(max_value, 1) == Err(Nil)
  assert checked_sub(0, 1) == Err(Nil)
  assert checked_mul(max_value, 2) == Err(Nil)
  assert checked_div(7, 0) == Err(Nil)
  assert checked_rem(7, 2) == Ok(1)
  assert checked_neg(0) == Ok(0)
  assert checked_neg(1) == Err(Nil)
}

test "u32 wrapping arithmetic wraps around" {
  assert wrapping_add(max_value, 1) == 0
  assert wrapping_sub(0, 1) == max_value
  assert wrapping_mul(max_value, 2) == max_value - 1
  assert wrapping_neg(1) == max_value
}

// Puzzle helpers. They sit at the end of the file, so no std location that
// a golden pins moves (D-1603).

/// Returns the greatest common divisor of `a` and `b`, and `0` for
/// `gcd(0, 0)` (D-1606).
pub fn gcd(a: U32, b: U32) -> U32 {
  case b {
    0 => a
    _ => gcd(b, a % b)
  }
}

/// Returns the least common multiple of `a` and `b`, and `0` when either
/// is `0` (D-1606). It panics when the result does not fit.
pub fn lcm(a: U32, b: U32) -> U32 {
  case a, b {
    0, _ => 0
    _, 0 => 0
    _, _ => a / gcd(a, b) * b
  }
}

test "u32 gcd and lcm" {
  assert gcd(12, 18) == 6
  assert gcd(0, 5) == 5
  assert gcd(0, 0) == 0
  assert gcd(max_value, 5) == 5
  assert lcm(4, 6) == 12
  assert lcm(0, 6) == 0
  assert lcm(max_value, 1) == max_value
}
