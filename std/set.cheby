//! The hashed set `Set<T>`, a persistent hash array mapped trie (§3.8,
//! D-039).
//!
//! `Set` is a builtin item whose home module is this one
//! (D-447, D-481), so it is not declared here. As in the spec's
//! signatures, it is written unqualified in this module
//! (D-481). Elements need no interface: they are compared
//! with `==` and hashed with the built-in structural hash (§3.13).
//! Iteration order depends on a per-process seed (D-093), so
//! `to_sorted_list` gives an order that is the same on every run. The
//! kernels are the functions set.md lists (D-274); the rest is written in
//! Cheby over them.

import std::int
import std::list
import std::map as maps
import std::ops::{Add, Compare}

// Building

/// Returns an empty set.
@external(native, "cheby_set_new")
@external(js, "./set.mjs", "new")
pub fn new<T>() -> Set<T>

test "new is empty" {
  let empty = new::<Int>()
  assert is_empty(empty)
  assert empty == from_list([])
}

/// Returns a set with the elements of `items`, each once.
@external(native, "cheby_set_from_list")
@external(js, "./set.mjs", "from_list")
pub fn from_list<T>(items: List<T>) -> Set<T>

test "from_list drops repeats" {
  let digits = from_list([3, 1, 3, 2])
  assert size(digits) == 3
  assert to_sorted_list(digits) == [1, 2, 3]
}

// Size

/// Returns the number of elements (D-301).
@external(native, "cheby_set_size")
@external(js, "./set.mjs", "size")
pub fn size<T>(s: Set<T>) -> Int

test "size counts elements" {
  assert size(from_list(["a", "b", "a"])) == 2
  assert size(new::<String>()) == 0
}

/// Tells whether the set has no elements.
@external(native, "cheby_set_is_empty")
@external(js, "./set.mjs", "is_empty")
pub fn is_empty<T>(s: Set<T>) -> Bool

test "is_empty tells an empty set" {
  assert is_empty(new::<Int>())
  assert !is_empty(from_list([0]))
}

// Lookup

/// Tells whether `item` is in the set.
@external(native, "cheby_set_contains")
@external(js, "./set.mjs", "contains")
pub fn contains<T>(s: Set<T>, item: T) -> Bool

test "contains looks an element up" {
  let seen = from_list(["/", "/a"])
  assert contains(seen, "/a")
  assert !contains(seen, "/b")
}

// Updating

/// Returns the set with `item` added, or unchanged when `item` is already in it.
@external(native, "cheby_set_insert")
@external(js, "./set.mjs", "insert")
pub fn insert<T>(s: Set<T>, item: T) -> Set<T>

test "insert adds an element once" {
  let start = from_list([1])
  let grown = insert(insert(start, 2), 2)
  assert grown == from_list([1, 2])
  assert start == from_list([1])
  assert list::fold([3, 4, 3], start, insert) == from_list([1, 3, 4])
}

/// Returns the set without `item`, or unchanged when `item` is not in it.
@external(native, "cheby_set_remove")
@external(js, "./set.mjs", "remove")
pub fn remove<T>(s: Set<T>, item: T) -> Set<T>

test "remove drops an element and ignores a missing one" {
  let held = from_list([1, 2])
  assert remove(held, 1) == from_list([2])
  assert remove(held, 5) == held
}

// Iterating

/// Returns the elements, in the set's per-process order (D-093).
@external(native, "cheby_set_to_list")
@external(js, "./set.mjs", "to_list")
pub fn to_list<T>(s: Set<T>) -> List<T>

test "to_list gives every element once" {
  let digits = from_list([2, 1, 2])
  assert list::sort(to_list(digits)) == [1, 2]
  assert from_list(to_list(digits)) == digits
}

/// Returns the elements sorted by `compare`, the same on every run (D-093, D-344).
pub fn to_sorted_list<T: Compare>(s: Set<T>) -> List<T> {
  list::sort_with(to_list(s), fn(a, b) { Compare::compare(a, b) })
}

test "to_sorted_list orders the elements" {
  assert to_sorted_list(from_list(["b", "c", "a"])) == ["a", "b", "c"]
  assert to_sorted_list(new::<Int>()) == []
}

/// Combines the elements, starting from `initial`, in the set's per-process order (D-093).
pub fn fold<T, A>(s: Set<T>, initial: A, f: fn(A, T) -> A) -> A {
  list::fold(to_list(s), initial, f)
}

test "fold visits every element once" {
  let digits = from_list([1, 2, 3])
  assert fold(digits, 0, int::add) == 6
  let grown = fold(digits, digits, fn(found, n) { insert(found, n * 10) })
  assert grown == from_list([1, 2, 3, 10, 20, 30])
}

/// Calls `f` once per element, in the set's per-process order (D-093), for its effects.
pub fn each<T>(s: Set<T>, f: fn(T)) {
  list::each(to_list(s), f)
}

test "each calls the function once per element" {
  each(from_list([1, 2, 3]), fn(n) { assert n > 0 })
}

/// Combines the elements like `fold`, in the set's per-process order
/// (D-093), and stops at the first `Err` that `f` returns (D-1080, D-1082).
/// It walks `to_list`, so the list is built before the first call.
pub fn try_fold<T, A, E>(s: Set<T>, initial: A, f: fn(A, T) -> Result<A, E>) -> Result<A, E> {
  list::try_fold(to_list(s), initial, f)
}

test "try_fold stops at the first error" {
  fn add_positive(total: Int, n: Int) -> Result<Int, Int> {
    case n > 0 {
      True => Ok(total + n)
      False => Err(n)
    }
  }
  assert try_fold(from_list([1, 2, 3]), 0, add_positive) == Ok(6)
  assert try_fold(from_list([1, -2, 3]), 0, add_positive) == Err(-2)
  assert try_fold(new(), 7, add_positive) == Ok(7)
  let stops = try_fold(from_list([1, 2, 3]), 0, fn(calls, _) {
    case calls {
      0 => Err("stopped")
      _ => panic as "not reached"
    }
  })
  assert stops == Err("stopped")
}

/// Tells whether `predicate` returns `True` for some element, stopping at
/// the first such element (D-1082).
pub fn any<T>(s: Set<T>, predicate: fn(T) -> Bool) -> Bool {
  list::any(to_list(s), predicate)
}

test "any looks for a matching element" {
  let digits = from_list([1, 2, 3])
  assert any(digits, fn(n) { n > 2 })
  assert !any(digits, fn(n) { n > 3 })
  assert !any(new::<Int>(), fn(_) { True })
}

/// Tells whether `predicate` returns `True` for every element, stopping at
/// the first element for which it returns `False` (D-1082).
pub fn all<T>(s: Set<T>, predicate: fn(T) -> Bool) -> Bool {
  list::all(to_list(s), predicate)
}

test "all needs every element to match" {
  let digits = from_list([1, 2, 3])
  assert all(digits, fn(n) { n > 0 })
  assert !all(digits, fn(n) { n > 1 })
  assert all(new::<Int>(), fn(_) { False })
}

/// Returns an element for which `predicate` returns `True`, the first in
/// the set's per-process order (D-093), so which of several matches it
/// returns can change between runs (D-1082).
pub fn find<T>(s: Set<T>, predicate: fn(T) -> Bool) -> Option<T> {
  list::find(to_list(s), predicate)
}

test "find returns a matching element" {
  let digits = from_list([1, 2, 3])
  assert find(digits, fn(n) { n > 2 }) == Some(3)
  assert find(digits, fn(n) { n > 3 }) == None
}

// Transforming

/// Returns the elements for which `keep` returns `True`.
pub fn filter<T>(s: Set<T>, keep: fn(T) -> Bool) -> Set<T> {
  list::fold(to_list(s), s, fn(kept, item) {
    case keep(item) {
      True => kept
      False => remove(kept, item)
    }
  })
}

test "filter keeps the matching elements" {
  let digits = from_list([1, 2, 3, 4])
  assert filter(digits, fn(n) { n % 2 == 0 }) == from_list([2, 4])
}

/// Returns the set of the results of `f`, merging results that are `==`.
pub fn map<T, U>(s: Set<T>, f: fn(T) -> U) -> Set<U> {
  from_list(list::map(to_list(s), f))
}

test "map can merge elements" {
  let digits = from_list([1, 2, 3, 4])
  assert map(digits, fn(n) { n / 2 }) == from_list([0, 1, 2])
}

// Combining

/// Returns the elements that are in `s` or in `other`. Where both hold
/// an element, the one in `s` is kept (D-588). It walks the smaller set.
pub fn union<T>(s: Set<T>, other: Set<T>) -> Set<T> {
  case size(other) <= size(s) {
    True => fold(other, s, insert)
    // Each element of `s` replaces the equal element of `other`, so the
    // result keeps the elements of `s`, as inserting into `s` does.
    False => fold(s, other, fn(found, item) { insert(remove(found, item), item) })
  }
}

test "union joins two sets" {
  let low = from_list([1, 2, 3])
  let high = from_list([3, 4])
  assert union(low, high) == from_list([1, 2, 3, 4])
}

test "union keeps the elements of its first set" {
  let small = from_list([-0.0])
  let large = from_list([0.0, 1.0, 2.0])
  let from_small = union(small, large)
  let from_large = union(large, small)
  assert "{from_small:?}" == "set::from_list([-0.0, 1.0, 2.0])"
  assert "{from_large:?}" == "set::from_list([0.0, 1.0, 2.0])"
}

/// Returns the elements of `s` that are also in `other`. It walks the
/// smaller set.
pub fn intersection<T>(s: Set<T>, other: Set<T>) -> Set<T> {
  case size(s) <= size(other) {
    True => filter(s, fn(item) { contains(other, item) })
    // `sys_get` gives the element that `s` holds, which can print
    // differently from the equal element of `other` (D-588).
    False => fold(other, new(), fn(found, item) {
      case sys_get(s, item) {
        Some(stored) => insert(found, stored)
        None => found
      }
    })
  }
}

/// The element of `s` that is `==` to `item`.
@external(native, "cheby_set_sys_get")
@external(js, "./set.mjs", "sys_get")
priv fn sys_get<T>(s: Set<T>, item: T) -> Option<T>

test "intersection keeps the shared elements" {
  let low = from_list([1, 2, 3])
  let high = from_list([2, 3, 4])
  assert intersection(low, high) == from_list([2, 3])
}

test "intersection keeps the elements of its first set" {
  let small = from_list([-0.0, 5.0])
  let large = from_list([0.0, 1.0, 2.0])
  let from_small = intersection(small, large)
  let from_large = intersection(large, small)
  assert "{from_small:?}" == "set::from_list([-0.0])"
  assert "{from_large:?}" == "set::from_list([0.0])"
}

/// Returns the elements of `s` that are not in `other`. It walks the
/// smaller set.
pub fn difference<T>(s: Set<T>, other: Set<T>) -> Set<T> {
  case size(other) < size(s) {
    True => fold(other, s, remove)
    False => filter(s, fn(item) { !contains(other, item) })
  }
}

test "difference removes the elements of the second set" {
  let low = from_list([1, 2, 3])
  let high = from_list([2, 3, 4])
  assert difference(low, high) == from_list([1])
}

test "difference gives the same set from either size" {
  let many = from_list([1, 2, 3, 4, 5])
  let few = from_list([2, 9])
  assert difference(many, few) == from_list([1, 3, 4, 5])
  assert difference(few, many) == from_list([9])
}

/// Tells whether every element of `s` is in `other`, stopping at the first
/// that is not. A larger `s` is never a subset, and gives `False` at once.
pub fn is_subset<T>(s: Set<T>, other: Set<T>) -> Bool {
  size(s) <= size(other) && list::all(to_list(s), fn(item) { contains(other, item) })
}

test "is_subset checks every element" {
  let small = from_list([1, 2])
  let large = from_list([1, 2, 3])
  assert is_subset(small, large)
  assert !is_subset(large, small)
  assert is_subset(new(), small)
}

// Tests of `std::map` that need this module.

test "maps compare by contents and print sorted" {
  let numbers = maps::from_list([(10, "ten"), (9, "nine")])
  assert numbers == maps::from_list([(9, "nine"), (10, "ten")])
  let nine = maps::insert(maps::new(), 9, "nine")
  assert size(from_list([numbers, nine])) == 2
  assert "{numbers:?}" == "map::from_list([(10, \"ten\"), (9, \"nine\")])"
}

// Examples

test "sets compare by contents and print sorted" {
  let words = from_list(["pear", "apple", "pear"])
  assert words == from_list(["apple", "pear"])
  assert "{words:?}" == "set::from_list([\"apple\", \"pear\"])"
}

// Puzzle helpers. They sit at the end of the file, so no std location that
// a golden pins moves (D-1603).

/// Returns the number of elements for which `predicate` returns `True`,
/// calling it once per element in the set's per-process order (D-093,
/// D-1650).
pub fn count<T>(s: Set<T>, predicate: fn(T) -> Bool) -> Int {
  list::count(to_list(s), predicate)
}

test "count counts the matching elements" {
  let digits = from_list([1, 2, 3, 4])
  assert count(digits, fn(n) { n % 2 == 0 }) == 2
  assert count(digits, fn(n) { n > 4 }) == 0
  assert count(new::<Int>(), fn(_) { True }) == 0
}

/// Adds the elements to `zero` in sorted order, so the result is the same
/// on every run and every target (D-1650).
pub fn sum<T: Add + Compare>(s: Set<T>, zero: T) -> T {
  list::sum(to_sorted_list(s), zero)
}

test "sum adds every element once" {
  assert sum(from_list([1, 2, 3, 2]), 0) == 6
  assert sum(new::<Int>(), 0) == 0
  assert sum(from_list([0.5, 0.25]), 0.0) == 0.75
}

test "sum adds in sorted order" {
  // Sorted, the 1.0 is lost against -1.0e16. An order that added the two
  // large values first would keep it and give 1.0.
  assert sum(from_list([1.0, -1.0e16, 1.0e16]), 0.0) == 0.0
}
