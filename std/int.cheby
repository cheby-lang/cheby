//! The built-in `Int`, a signed 64-bit integer: constants, conversions,
//! parsing and text, comparison, and checked, floored and wrapping arithmetic.
//!
//! `Int` itself is a builtin item whose home module is this one (D-447).
//! The functions on operators exist to be passed as values and to satisfy
//! `Compare`, `Show`, `Add`, `Sub`, `Mul`, `Div` and `Neg`.

// Constants

/// The smallest `Int`, -2^63. It exists only on native (D-358).
@target(native)
pub const min_value: Int = -9_223_372_036_854_775_808

@target(native)
test "min_value is the smallest Int" {
  assert min_value == -max_value - 1
  assert checked_sub(min_value, 1) == Err(Nil)
}

/// The largest `Int`, 2^63-1. It exists only on native (D-358).
@target(native)
pub const max_value: Int = 9_223_372_036_854_775_807

@target(native)
test "max_value is the largest Int" {
  assert max_value == pow(2, 62) - 1 + pow(2, 62)
  assert min_value + max_value == -1
}

/// The smallest `Int` that works on every target, -(2^53-1) (D-037).
pub const min_safe: Int = -9_007_199_254_740_991

test "min_safe is the negated max_safe" {
  assert min_safe == -9_007_199_254_740_991
  assert min_safe == -max_safe
}

/// The largest `Int` that works on every target, 2^53-1 (D-037).
pub const max_safe: Int = 9_007_199_254_740_991

test "max_safe is the largest portable Int" {
  assert max_safe == 9_007_199_254_740_991
  assert checked_sub(max_safe, 1) == Ok(9_007_199_254_740_990)
}

// Conversions

/// Returns `n` as an `Int`. Every `I8` fits.
@external(native, "cheby_int_from_i8")
@external(js, "./int.mjs", "from_i8")
pub fn from_i8(n: I8) -> Int

/// Returns `n` as an `Int`. Every `I16` fits.
@external(native, "cheby_int_from_i16")
@external(js, "./int.mjs", "from_i16")
pub fn from_i16(n: I16) -> Int

test "from_i16 widens" {
  assert from_i16(-32_768) == -32_768
}

/// Returns `n` as an `Int`. Every `I32` fits.
@external(native, "cheby_int_from_i32")
@external(js, "./int.mjs", "from_i32")
pub fn from_i32(n: I32) -> Int

/// Returns `n` as an `Int`, or `Err(Nil)` when it does not fit.
@external(native, "cheby_int_from_i64")
@external(js, "./int.mjs", "from_i64")
pub fn from_i64(n: I64) -> Result<Int, Nil>

test "from_i64 converts a small value on every target" {
  assert from_i64(-42) == Ok(-42)
}

/// Returns `n` as an `Int`. Every `U8` fits.
@external(native, "cheby_int_from_u8")
@external(js, "./int.mjs", "from_u8")
pub fn from_u8(n: U8) -> Int

test "from_u8 widens" {
  assert from_u8(255) == 255
}

/// Returns `n` as an `Int`. Every `U16` fits.
@external(native, "cheby_int_from_u16")
@external(js, "./int.mjs", "from_u16")
pub fn from_u16(n: U16) -> Int

/// Returns `n` as an `Int`. Every `U32` fits.
@external(native, "cheby_int_from_u32")
@external(js, "./int.mjs", "from_u32")
pub fn from_u32(n: U32) -> Int

/// Returns `n` as an `Int`, or `Err(Nil)` when it does not fit.
@external(native, "cheby_int_from_u64")
@external(js, "./int.mjs", "from_u64")
pub fn from_u64(n: U64) -> Result<Int, Nil>

/// Returns `n` as an `Int`, which keeps every bit (D-1091). On JS it panics
/// outside ±(2⁵³−1), like `from_i64` (D-037).
pub fn wrapping_from_i64(n: I64) -> Int {
  let assert Ok(value) = from_i64(n)
  value
}

test "wrapping_from_i64 keeps the value" {
  assert wrapping_from_i64(-42) == -42
  assert wrapping_from_i64(0) == 0
}

@target(native)
test "wrapping_from_i64 keeps every I64 on native" {
  assert wrapping_from_i64(9_223_372_036_854_775_807) == max_value
  assert wrapping_from_i64(-9_223_372_036_854_775_808) == min_value
}

/// Reads the 64 bits of `n` as a two's-complement `Int` (D-1091). On JS it
/// panics where the result is outside ±(2⁵³−1) (D-037).
pub fn wrapping_from_u64(n: U64) -> Int {
  case n < 0x8000_0000_0000_0000 {
    True => {
      let assert Ok(value) = from_u64(n)
      value
    }
    False => {
      // `0xFFFF_FFFF_FFFF_FFFF - n` fits, and minus it minus 1 is `n` - 2^64.
      let assert Ok(complement) = from_u64(0xFFFF_FFFF_FFFF_FFFF - n)
      -complement - 1
    }
  }
}

test "wrapping_from_u64 reads the bits as two's complement" {
  assert wrapping_from_u64(42) == 42
  assert wrapping_from_u64(18_446_744_073_709_551_615) == -1
  assert wrapping_from_u64(18_446_744_073_709_551_574) == -42
}

test "wrapping_from_u64 keeps safe values on every target" {
  assert wrapping_from_u64(0) == 0
  assert wrapping_from_u64(9_007_199_254_740_991) == max_safe
  assert wrapping_from_u64(18_437_736_874_454_810_625) == min_safe
}

@target(native)
test "wrapping_from_u64 covers every Int on native" {
  assert wrapping_from_u64(9_223_372_036_854_775_807) == max_value
  assert wrapping_from_u64(9_223_372_036_854_775_808) == min_value
  assert wrapping_from_u64(9_223_372_036_854_775_809) == min_value + 1
}

// Parsing and text

/// Reads an `Int` written as an optional `-` and ASCII decimal digits (D-312).
@external(native, "cheby_int_parse")
@external(js, "./int.mjs", "parse")
pub fn parse(text: String) -> Result<Int, Nil>

test "parse reads an optional minus and decimal digits" {
  assert parse("42") == Ok(42)
  assert parse("-007") == Ok(-7)
  assert parse("+42") == Err(Nil)
  assert parse(" 42") == Err(Nil)
  assert parse("1_000") == Err(Nil)
  assert parse("0x2A") == Err(Nil)
  assert parse("-") == Err(Nil)
  assert parse("") == Err(Nil)
  assert parse("9223372036854775808") == Err(Nil)
}

/// Reads an `Int` written in `base`, from 2 to 36, as an optional `-` and digits.
@external(native, "cheby_int_parse_base")
@external(js, "./int.mjs", "parse_base")
pub fn parse_base(text: String, base: Int) -> Result<Int, Nil>

test "parse_base reads other bases" {
  assert parse_base("ff", 16) == Ok(255)
  assert parse_base("FF", 16) == Ok(255)
  assert parse_base("-101", 2) == Ok(-5)
  assert parse_base("z", 36) == Ok(35)
  assert parse_base("12", 2) == Err(Nil)
  assert parse_base("0xff", 16) == Err(Nil)
  assert parse_base("1", 37) == Err(Nil)
}

/// Returns `n` in decimal. It makes `Int` satisfy `Show`.
@external(native, "cheby_int_show")
@external(js, "./int.mjs", "show")
pub fn show(n: Int) -> String

test "show writes decimal digits" {
  let count = 3
  assert show(-42) == "-42"
  assert show(0) == "0"
  assert "{count} items" == "3 items"
  assert parse(show(-1234)) == Ok(-1234)
}

/// Returns `n` written in `base`, from 2 to 36, in lowercase digits (D-390).
@external(native, "cheby_int_to_base")
@external(js, "./int.mjs", "to_base")
pub fn to_base(n: Int, base: Int) -> Result<String, Nil>

test "to_base writes other bases" {
  assert to_base(255, 16) == Ok("ff")
  assert to_base(-5, 2) == Ok("-101")
  assert to_base(0, 8) == Ok("0")
  assert to_base(10, 1) == Err(Nil)
  assert parse_base("7b", 16) == Ok(123)
  assert to_base(123, 16) == Ok("7b")
}

// Comparison

/// Orders two `Int` values. It makes `Int` satisfy `Compare`.
pub fn compare(a: Int, b: Int) -> Order {
  case {
    a < b => Less
    a > b => Greater
    _ => Equal
  }
}

/// Returns the smaller of `a` and `b`, and `a` when they are `Equal`.
pub fn min(a: Int, b: Int) -> Int {
  case {
    b < a => b
    _ => a
  }
}

test "min picks the smaller" {
  assert min(3, 7) == 3
  assert min(-3, -7) == -7
}

/// Returns the larger of `a` and `b`, and `a` when they are `Equal`.
pub fn max(a: Int, b: Int) -> Int {
  case {
    b > a => b
    _ => a
  }
}

/// Returns `n` limited to `low` to `high`, and `low` when `low` is above `high`.
pub fn clamp(n: Int, low: Int, high: Int) -> Int {
  max(min(n, high), low)
}

test "clamp limits to a range" {
  assert clamp(15, 0, 10) == 10
  assert clamp(-3, 0, 10) == 0
  assert clamp(4, 0, 10) == 4
  assert clamp(4, 10, 0) == 10
}

// Arithmetic

/// Returns `a + b`, and panics when the result does not fit. It makes `Int` satisfy `Add`.
pub fn add(a: Int, b: Int) -> Int {
  a + b
}

/// Returns `a - b`, and panics when the result does not fit. It makes `Int` satisfy `Sub`.
pub fn sub(a: Int, b: Int) -> Int {
  a - b
}

test "sub is minus as a function" {
  assert sub(2, 3) == -1
}

/// Returns `a * b`, and panics when the result does not fit. It makes `Int` satisfy `Mul`.
pub fn mul(a: Int, b: Int) -> Int {
  a * b
}

/// Returns `a / b` toward zero, panicking like `/`. It makes `Int` satisfy `Div`.
pub fn div(a: Int, b: Int) -> Int {
  a / b
}

test "div truncates toward zero" {
  assert div(7, 2) == 3
  assert div(-7, 2) == -3
}

/// Returns `a % b`, with the sign of `a`, and panics on a zero divisor.
pub fn rem(a: Int, b: Int) -> Int {
  a % b
}

test "rem keeps the sign of the dividend" {
  assert rem(7, 2) == 1
  assert rem(-7, 2) == -1
  assert rem(7, -2) == 1
}

/// Returns `a / b` rounded toward negative infinity, panicking like `/` (D-1056).
pub fn floor_div(a: Int, b: Int) -> Int {
  // `/` panics first for a zero divisor and for `min_value / -1`. The
  // quotient moves down only when the signs differ, where `q - 1` cannot
  // overflow.
  let q = a / b
  case {
    a % b != 0 && (a < 0) != (b < 0) => q - 1
    _ => q
  }
}

test "floor_div and modulo round toward negative infinity" {
  assert floor_div(-7, 2) == -4
  assert floor_div(7, -2) == -4
  assert modulo(-1, 10) == 9
  assert modulo(7, -2) == -1
  assert checked_modulo(1, 0) == Err(Nil)
}

test "floor_div equals div when the signs agree or the division is exact" {
  assert floor_div(7, 2) == 3
  assert floor_div(-7, -2) == 3
  assert floor_div(-6, 2) == -3
  assert floor_div(0, -5) == 0
}

/// Returns the remainder of `floor_div`, with the sign of `b`, panicking like `%` (D-1056).
pub fn modulo(a: Int, b: Int) -> Int {
  // `r + b` adds values of opposite signs, so it cannot overflow.
  let r = a % b
  case {
    r != 0 && (r < 0) != (b < 0) => r + b
    _ => r
  }
}

test "modulo takes the sign of the divisor" {
  assert modulo(12, 5) == 2
  assert modulo(-12, 5) == 3
  assert modulo(12, -5) == -3
  assert modulo(-12, -5) == -2
  assert modulo(-10, 5) == 0
}

test "floor_div and modulo rebuild the dividend" {
  fn rebuilds(pairs) {
    case pairs {
      [] => True
      [(a, b), ..rest] => a == floor_div(a, b) * b + modulo(a, b) && rebuilds(rest)
    }
  }
  assert rebuilds([(7, 3), (-7, 3), (7, -3), (-7, -3), (0, 4), (9, 1), (-9, -1)])
}

/// Returns `-n`, and panics when it does not fit. It makes `Int` satisfy `Neg`.
pub fn neg(n: Int) -> Int {
  -n
}

test "neg flips the sign" {
  assert neg(5) == -5
  assert neg(-5) == 5
  assert neg(0) == 0
}

/// Returns `n` without its sign, and panics for `min_value`, like `neg`.
pub fn abs(n: Int) -> Int {
  case {
    n < 0 => -n
    _ => n
  }
}

test "abs drops the sign" {
  assert abs(-5) == 5
  assert abs(5) == 5
}

/// Returns `n` to the power `exponent`, and panics when the result does not fit.
@std_clamped(exponent)
pub fn pow(n: Int, exponent: Int) -> Int {
  // Squaring by halves. A base is squared only while at least two
  // factors remain, so no step overflows unless the result does.
  fn step(base: Int, times: Int, product: Int) -> Int {
    case {
      times <= 0 => product
      times == 1 => product * base
      times % 2 == 1 => step(base * base, times / 2, product * base)
      _ => step(base * base, times / 2, product)
    }
  }
  step(n, exponent, 1)
}

test "pow multiplies repeatedly" {
  let below_zero = -2
  assert pow(2, 10) == 1024
  assert pow(-3, 3) == -27
  assert pow(0, 0) == 1
  assert pow(10, below_zero) == 1
}

// Checked arithmetic

/// Returns `Ok(a + b)`, or `Err(Nil)` when the sum does not fit (D-309).
@external(native, "cheby_int_checked_add")
@external(js, "./int.mjs", "checked_add")
pub fn checked_add(a: Int, b: Int) -> Result<Int, Nil>

test "checked_add returns a sum that fits" {
  assert checked_add(1, 2) == Ok(3)
}

@target(native)
test "checked_add reports overflow" {
  assert checked_add(max_value, 1) == Err(Nil)
  assert checked_add(min_value, -1) == Err(Nil)
}

/// Returns `Ok(a - b)`, or `Err(Nil)` when the difference does not fit (D-309).
@external(native, "cheby_int_checked_sub")
@external(js, "./int.mjs", "checked_sub")
pub fn checked_sub(a: Int, b: Int) -> Result<Int, Nil>

test "checked_sub returns a difference that fits" {
  assert checked_sub(1, 3) == Ok(-2)
}

@target(native)
test "checked_sub reports overflow" {
  assert checked_sub(min_value, 1) == Err(Nil)
}

/// Returns `Ok(a * b)`, or `Err(Nil)` when the product does not fit (D-309).
@external(native, "cheby_int_checked_mul")
@external(js, "./int.mjs", "checked_mul")
pub fn checked_mul(a: Int, b: Int) -> Result<Int, Nil>

test "checked_mul returns a product that fits" {
  assert checked_mul(-4, 5) == Ok(-20)
}

@target(native)
test "checked_mul reports overflow" {
  assert checked_mul(max_value, 2) == Err(Nil)
}

/// Returns `Ok(a / b)`, or `Err(Nil)` for a zero divisor and for `min_value / -1` (D-356).
pub fn checked_div(a: Int, b: Int) -> Result<Int, Nil> {
  // Dividing by -1 overflows exactly when negating does.
  case b {
    0 => Err(Nil)
    -1 => checked_neg(a)
    _ => Ok(a / b)
  }
}

test "checked_div reports a zero divisor" {
  assert checked_div(7, 2) == Ok(3)
  assert checked_div(-7, 2) == Ok(-3)
  assert checked_div(7, 0) == Err(Nil)
}

@target(native)
test "checked_div reports overflow" {
  assert checked_div(min_value, -1) == Err(Nil)
}

/// Returns `Ok(a % b)`, or `Err(Nil)` for a zero divisor (D-356).
pub fn checked_rem(a: Int, b: Int) -> Result<Int, Nil> {
  case b {
    0 => Err(Nil)
    _ => Ok(a % b)
  }
}

test "checked_rem reports a zero divisor" {
  assert checked_rem(-7, 2) == Ok(-1)
  assert checked_rem(7, 0) == Err(Nil)
}

/// Returns `Ok(floor_div(a, b))`, or `Err(Nil)` for a zero divisor and for `min_value / -1` (D-1056).
pub fn checked_floor_div(a: Int, b: Int) -> Result<Int, Nil> {
  // Dividing by -1 is exact, so it overflows exactly when negating does.
  case b {
    0 => Err(Nil)
    -1 => checked_neg(a)
    _ => Ok(floor_div(a, b))
  }
}

test "checked_floor_div reports a zero divisor" {
  assert checked_floor_div(-7, 2) == Ok(-4)
  assert checked_floor_div(7, -1) == Ok(-7)
  assert checked_floor_div(7, 0) == Err(Nil)
}

@target(native)
test "checked_floor_div reports overflow" {
  assert checked_floor_div(min_value, -1) == Err(Nil)
}

/// Returns `Ok(modulo(a, b))`, or `Err(Nil)` for a zero divisor (D-1056).
pub fn checked_modulo(a: Int, b: Int) -> Result<Int, Nil> {
  case b {
    0 => Err(Nil)
    _ => Ok(modulo(a, b))
  }
}

test "checked_modulo reports a zero divisor" {
  assert checked_modulo(-1, 10) == Ok(9)
  assert checked_modulo(-1, 0) == Err(Nil)
}

// `min_value` exists only on native, so `checked_neg` cannot test for it
// portably. `checked_pow` over `checked_mul` would panic on JS for an
// intermediate product past 2^53 where the result must be `Err(Nil)`.
// Both are kernels.

/// Returns `Ok(-n)`, or `Err(Nil)` for `min_value` (D-309).
@external(native, "cheby_int_checked_neg")
@external(js, "./int.mjs", "checked_neg")
pub fn checked_neg(n: Int) -> Result<Int, Nil>

test "checked_neg negates" {
  assert checked_neg(5) == Ok(-5)
}

@target(native)
test "checked_neg reports overflow" {
  assert checked_neg(min_value) == Err(Nil)
}

/// Returns `Ok(pow(n, exponent))`, or `Err(Nil)` when the result does not fit (D-392).
@external(native, "cheby_int_checked_pow")
@external(js, "./int.mjs", "checked_pow")
@std_clamped(exponent)
pub fn checked_pow(n: Int, exponent: Int) -> Result<Int, Nil>

test "checked_pow returns a power that fits" {
  assert checked_pow(2, 10) == Ok(1024)
}

@target(native)
test "checked_pow reports overflow" {
  assert checked_pow(2, 62) == Ok(max_value / 2 + 1)
  assert checked_pow(2, 63) == Err(Nil)
}

// Wrapping arithmetic

/// Returns `a + b` modulo 2^64 (D-025).
@external(native, "cheby_int_wrapping_add")
@external(js, "./int.mjs", "wrapping_add")
pub fn wrapping_add(a: Int, b: Int) -> Int

@target(native)
test "wrapping_add wraps around" {
  assert wrapping_add(2, 3) == 5
  assert wrapping_add(max_value, 1) == min_value
}

/// Returns `a - b` modulo 2^64 (D-025).
@external(native, "cheby_int_wrapping_sub")
@external(js, "./int.mjs", "wrapping_sub")
pub fn wrapping_sub(a: Int, b: Int) -> Int

@target(native)
test "wrapping_sub wraps around" {
  assert wrapping_sub(2, 3) == -1
  assert wrapping_sub(min_value, 1) == max_value
}

/// Returns `a * b` modulo 2^64 (D-025).
@external(native, "cheby_int_wrapping_mul")
@external(js, "./int.mjs", "wrapping_mul")
pub fn wrapping_mul(a: Int, b: Int) -> Int

@target(native)
test "wrapping_mul wraps around" {
  assert wrapping_mul(-4, 5) == -20
  assert wrapping_mul(max_value, 2) == -2
}

/// Returns `-n` modulo 2^64 (D-025).
@external(native, "cheby_int_wrapping_neg")
@external(js, "./int.mjs", "wrapping_neg")
pub fn wrapping_neg(n: Int) -> Int

@target(native)
test "wrapping_neg wraps around" {
  assert wrapping_neg(5) == -5
  assert wrapping_neg(min_value) == min_value
}

// Puzzle helpers. They sit at the end of the file, so no std location that
// a golden pins moves (D-1603).

/// Returns every integer written in `text`, in order (D-1605). A number is
/// a run of the ASCII digits `0` to `9`, and a `-` right before the run
/// makes it negative unless the character before that `-` is a digit too,
/// so `"2-4"` gives `[2, 4]` and `"p=3,-4"` gives `[3, -4]`. Every other
/// character separates numbers, and a run that does not fit panics.
pub fn find_all(text: String) -> List<Int> {
  find_numbers(code_points(text), False, [])
}

/// Walks `rest` between numbers. `after_digit` tells whether the code
/// point before `rest` is a digit, which stops a `-` from being a sign.
priv fn find_numbers(rest: List<Int>, after_digit: Bool, found: List<Int>) -> List<Int> {
  case rest {
    [] => found
    [45, d, ..tail] when !after_digit && is_digit(d) => read_digits(tail, 48 - d, -1, found)
    [c, ..tail] when is_digit(c) => read_digits(tail, c - 48, 1, found)
    [_, ..tail] => find_numbers(tail, False, found)
  }
}

/// Reads the rest of a number whose value so far is `value`. A negative
/// number is built downward, so `min_value` fits.
priv fn read_digits(rest: List<Int>, value: Int, sign: Int, found: List<Int>) -> List<Int> {
  case rest {
    [c, ..tail] when is_digit(c) => read_digits(tail, value * 10 + sign * (c - 48), sign, found)
    _ => find_numbers(rest, True, [..found, value])
  }
}

/// Whether the code point `c` is an ASCII decimal digit.
priv fn is_digit(c: Int) -> Bool {
  c >= 48 && c <= 57
}

/// `string::to_code_point_values`'s own kernel, for `find_all`. A call of
/// `std::string` would make every program that uses `std::int` compile all
/// of `std::string` and `std::bytes` with it (D-1177, D-1605).
@external(native, "cheby_string_to_code_point_values")
@external(js, "./string.mjs", "to_code_point_values")
priv fn code_points(text: String) -> List<Int>

test "find_all reads every integer in order" {
  assert find_all("p=3,-4 v=12") == [3, -4, 12]
  assert find_all("Game 17: 3 blue, 40 red") == [17, 3, 40]
  assert find_all("x=-5..-3") == [-5, -3]
  assert find_all("007") == [7]
  assert find_all("") == []
  assert find_all("no numbers") == []
}

test "find_all reads a dash between digits as a separator" {
  assert find_all("2-4,6-8") == [2, 4, 6, 8]
  assert find_all("1--2") == [1, -2]
  assert find_all("-") == []
  assert find_all("a-b-3") == [-3]
}

test "find_all takes no plus sign and only ASCII digits" {
  assert find_all("+5 -6") == [5, -6]
  assert find_all("1.5") == [1, 5]
  assert find_all("٣ 4") == [4]
  assert find_all("line\r\n12\n") == [12]
}

@target(native)
test "find_all reads the limits of Int" {
  assert find_all("-9223372036854775808 9223372036854775807") == [min_value, max_value]
}

/// Returns the greatest common divisor of `a` and `b`, which is never
/// negative, and `0` for `gcd(0, 0)` (D-1606). It panics only when the
/// result does not fit, as for `gcd(min_value, 0)`.
pub fn gcd(a: Int, b: Int) -> Int {
  // Euclid's steps on values made non-positive, whose range holds the
  // negation of every `Int`, so only the last `-` can overflow.
  fn step(x: Int, y: Int) -> Int {
    case y {
      0 => -x
      _ => step(y, x % y)
    }
  }
  step(non_positive(a), non_positive(b))
}

/// `n` with its sign made negative, which always fits.
priv fn non_positive(n: Int) -> Int {
  case {
    n > 0 => -n
    _ => n
  }
}

/// Returns the least common multiple of `a` and `b`, which is never
/// negative, and `0` when either is `0` (D-1606). It panics when the result
/// does not fit.
pub fn lcm(a: Int, b: Int) -> Int {
  case a, b {
    0, _ => 0
    _, 0 => 0
    _, _ => abs(a / gcd(a, b) * b)
  }
}

test "gcd is the greatest common divisor" {
  assert gcd(12, 18) == 6
  assert gcd(-12, 18) == 6
  assert gcd(12, -18) == 6
  assert gcd(7, 13) == 1
  assert gcd(0, 5) == 5
  assert gcd(-5, 0) == 5
  assert gcd(0, 0) == 0
}

test "lcm is the least common multiple" {
  assert lcm(4, 6) == 12
  assert lcm(-4, 6) == 12
  assert lcm(0, 6) == 0
  assert lcm(6, 0) == 0
  assert lcm(7, 7) == 7
}

@target(native)
test "gcd and lcm reach the limits of Int" {
  assert gcd(min_value, 6) == 2
  assert gcd(min_value, -1) == 1
  assert gcd(min_value, max_value) == 1
  assert lcm(max_value, 1) == max_value
  assert lcm(min_value + 1, -1) == max_value
}

/// Returns the values of the ASCII digits of `text`, in order, or
/// `Err(Nil)` when `text` is empty or holds any other character
/// (D-1654).
pub fn digits(text: String) -> Result<List<Int>, Nil> {
  fn step(rest: List<Int>, found: List<Int>) -> Result<List<Int>, Nil> {
    case rest {
      [] => Ok(found)
      [c, ..tail] when is_digit(c) => step(tail, [..found, c - 48])
      [_, ..] => Err(Nil)
    }
  }
  case text {
    "" => Err(Nil)
    _ => step(code_points(text), [])
  }
}

test "digits reads one digit per character" {
  assert digits("0123") == Ok([0, 1, 2, 3])
  assert digits("9") == Ok([9])
  assert digits("") == Err(Nil)
  assert digits("12a") == Err(Nil)
  assert digits("-1") == Err(Nil)
  assert digits("1 2") == Err(Nil)
  assert digits("4\n") == Err(Nil)
  assert digits("٣") == Err(Nil)
}

/// Returns the decimal digits of `n`'s absolute value, from the most
/// significant, so `to_digits(0)` is `[0]` (D-1654). It reads the digits
/// off the value made non-positive, which always fits.
pub fn to_digits(n: Int) -> List<Int> {
  fn step(rest: Int, found: List<Int>) -> List<Int> {
    let next = [0 - rest % 10, ..found]
    case rest / 10 {
      0 => next
      higher => step(higher, next)
    }
  }
  step(non_positive(n), [])
}

test "to_digits writes the digits of the absolute value" {
  assert to_digits(120) == [1, 2, 0]
  assert to_digits(-120) == [1, 2, 0]
  assert to_digits(0) == [0]
  assert to_digits(7) == [7]
  assert to_digits(max_safe) == [9, 0, 0, 7, 1, 9, 9, 2, 5, 4, 7, 4, 0, 9, 9, 1]
}

@target(native)
test "to_digits reaches the limits of Int" {
  assert to_digits(min_value) == [9, 2, 2, 3, 3, 7, 2, 0, 3, 6, 8, 5, 4, 7, 7, 5, 8, 0, 8]
}
