//! The built-in `U8`, a unsigned 8-bit integer: constants, conversions,
//! parsing and text, comparison, and checked and wrapping arithmetic
//! (the integer families of `docs/stdlib/README.md`, D-350).
//!
//! `U8` itself is a builtin item whose home module is this one (D-447).

import std::int

// Constants

/// The smallest `U8`.
pub const min_value: U8 = 0

/// The largest `U8`.
pub const max_value: U8 = 255

// Conversions

/// Returns `n` as an `U8`, or `Err(Nil)` when it does not fit.
@external(native, "cheby_u8_from_int")
@external(js, "./u8.mjs", "from_int")
pub fn from_int(n: Int) -> Result<U8, Nil>

/// Returns `n` as an `U8`, or `Err(Nil)` when it does not fit.
@external(native, "cheby_u8_from_i8")
@external(js, "./u8.mjs", "from_i8")
pub fn from_i8(n: I8) -> Result<U8, Nil>

/// Returns `n` as an `U8`, or `Err(Nil)` when it does not fit.
@external(native, "cheby_u8_from_i16")
@external(js, "./u8.mjs", "from_i16")
pub fn from_i16(n: I16) -> Result<U8, Nil>

/// Returns `n` as an `U8`, or `Err(Nil)` when it does not fit.
@external(native, "cheby_u8_from_i32")
@external(js, "./u8.mjs", "from_i32")
pub fn from_i32(n: I32) -> Result<U8, Nil>

/// Returns `n` as an `U8`, or `Err(Nil)` when it does not fit.
@external(native, "cheby_u8_from_i64")
@external(js, "./u8.mjs", "from_i64")
pub fn from_i64(n: I64) -> Result<U8, Nil>

/// Returns `n` as an `U8`, or `Err(Nil)` when it does not fit.
@external(native, "cheby_u8_from_u16")
@external(js, "./u8.mjs", "from_u16")
pub fn from_u16(n: U16) -> Result<U8, Nil>

/// Returns `n` as an `U8`, or `Err(Nil)` when it does not fit.
@external(native, "cheby_u8_from_u32")
@external(js, "./u8.mjs", "from_u32")
pub fn from_u32(n: U32) -> Result<U8, Nil>

/// Returns `n` as an `U8`, or `Err(Nil)` when it does not fit.
@external(native, "cheby_u8_from_u64")
@external(js, "./u8.mjs", "from_u64")
pub fn from_u64(n: U64) -> Result<U8, Nil>

/// Keeps the low 8 bits of `n`'s two's-complement value and reads them as a `U8` (D-1091).
pub fn wrapping_from_int(n: Int) -> U8 {
  let assert Ok(low) = from_int(n & 0xFF)
  low
}

/// Keeps the low 8 bits of `n`'s two's-complement value and reads them as a `U8` (D-1091).
pub fn wrapping_from_i8(n: I8) -> U8 {
  case n >= 0 {
    True => {
      let assert Ok(value) = from_i8(n)
      value
    }
    False => {
      // `-(n + 1)` fits, and `max_value` minus it is 2^8 + n.
      let assert Ok(complement) = from_i8(-(n + 1))
      max_value - complement
    }
  }
}

/// Keeps the low 8 bits of `n`'s two's-complement value and reads them as a `U8` (D-1091).
pub fn wrapping_from_i16(n: I16) -> U8 {
  let assert Ok(low) = from_i16(n & 0xFF)
  low
}

/// Keeps the low 8 bits of `n`'s two's-complement value and reads them as a `U8` (D-1091).
pub fn wrapping_from_i32(n: I32) -> U8 {
  let assert Ok(low) = from_i32(n & 0xFF)
  low
}

/// Keeps the low 8 bits of `n`'s two's-complement value and reads them as a `U8` (D-1091).
pub fn wrapping_from_i64(n: I64) -> U8 {
  let assert Ok(low) = from_i64(n & 0xFF)
  low
}

/// Keeps the low 8 bits of `n`'s two's-complement value and reads them as a `U8` (D-1091).
pub fn wrapping_from_u16(n: U16) -> U8 {
  let assert Ok(low) = from_u16(n & 0xFF)
  low
}

/// Keeps the low 8 bits of `n`'s two's-complement value and reads them as a `U8` (D-1091).
pub fn wrapping_from_u32(n: U32) -> U8 {
  let assert Ok(low) = from_u32(n & 0xFF)
  low
}

/// Keeps the low 8 bits of `n`'s two's-complement value and reads them as a `U8` (D-1091).
pub fn wrapping_from_u64(n: U64) -> U8 {
  let assert Ok(low) = from_u64(n & 0xFF)
  low
}

test "wrapping_from keeps the low 8 bits of every source" {
  assert wrapping_from_int(-1) == 255
  assert wrapping_from_int(0) == 0
  assert wrapping_from_int(1) == 1
  assert wrapping_from_int(255) == 255
  assert wrapping_from_int(256) == 0
  assert wrapping_from_i8(-128) == 128
  assert wrapping_from_i8(-17) == 239
  assert wrapping_from_i8(-1) == 255
  assert wrapping_from_i8(0) == 0
  assert wrapping_from_i8(1) == 1
  assert wrapping_from_i8(17) == 17
  assert wrapping_from_i8(127) == 127
  assert wrapping_from_i16(-32_768) == 0
  assert wrapping_from_i16(-12_817) == 239
  assert wrapping_from_i16(-1) == 255
  assert wrapping_from_i16(0) == 0
  assert wrapping_from_i16(1) == 1
  assert wrapping_from_i16(255) == 255
  assert wrapping_from_i16(256) == 0
  assert wrapping_from_i16(12_817) == 17
  assert wrapping_from_i16(32_767) == 255
  assert wrapping_from_i32(-2_147_483_648) == 0
  assert wrapping_from_i32(-1_985_229_329) == 239
  assert wrapping_from_i32(-1) == 255
  assert wrapping_from_i32(0) == 0
  assert wrapping_from_i32(1) == 1
  assert wrapping_from_i32(255) == 255
  assert wrapping_from_i32(256) == 0
  assert wrapping_from_i32(1_985_229_329) == 17
  assert wrapping_from_i32(2_147_483_647) == 255
  assert wrapping_from_i64(-9_223_372_036_854_775_808) == 0
  assert wrapping_from_i64(-81_985_529_216_486_895) == 17
  assert wrapping_from_i64(-1) == 255
  assert wrapping_from_i64(0) == 0
  assert wrapping_from_i64(1) == 1
  assert wrapping_from_i64(255) == 255
  assert wrapping_from_i64(256) == 0
  assert wrapping_from_i64(81_985_529_216_486_895) == 239
  assert wrapping_from_i64(9_223_372_036_854_775_807) == 255
  assert wrapping_from_u16(0) == 0
  assert wrapping_from_u16(1) == 1
  assert wrapping_from_u16(255) == 255
  assert wrapping_from_u16(256) == 0
  assert wrapping_from_u16(52_719) == 239
  assert wrapping_from_u16(65_535) == 255
  assert wrapping_from_u32(0) == 0
  assert wrapping_from_u32(1) == 1
  assert wrapping_from_u32(255) == 255
  assert wrapping_from_u32(256) == 0
  assert wrapping_from_u32(2_309_737_967) == 239
  assert wrapping_from_u32(4_294_967_295) == 255
  assert wrapping_from_u64(0) == 0
  assert wrapping_from_u64(1) == 1
  assert wrapping_from_u64(255) == 255
  assert wrapping_from_u64(256) == 0
  assert wrapping_from_u64(81_985_529_216_486_895) == 239
  assert wrapping_from_u64(18_446_744_073_709_551_615) == 255
}

@target(native)
test "wrapping_from_int keeps the low 8 bits of every Int" {
  assert wrapping_from_int(-9_223_372_036_854_775_808) == 0
  assert wrapping_from_int(-81_985_529_216_486_895) == 17
  assert wrapping_from_int(81_985_529_216_486_895) == 239
  assert wrapping_from_int(9_223_372_036_854_775_807) == 255
}

// Parsing and text

/// Reads an `U8` written as an optional `-` and ASCII decimal digits (D-312).
@external(native, "cheby_u8_parse")
@external(js, "./u8.mjs", "parse")
pub fn parse(text: String) -> Result<U8, Nil>

/// Reads an `U8` written in `base`, from 2 to 36, as an optional `-` and digits.
@external(native, "cheby_u8_parse_base")
@external(js, "./u8.mjs", "parse_base")
pub fn parse_base(text: String, base: Int) -> Result<U8, Nil>

/// Returns `n` written in `base`, from 2 to 36, in lowercase digits (D-390, D-1090).
pub fn to_base(n: U8, base: Int) -> Result<String, Nil> {
  int::to_base(int::from_u8(n), base)
}

test "to_base writes every U8 in every base" {
  assert to_base(0, 2) == Ok("0")
  assert to_base(0, 8) == Ok("0")
  assert to_base(0, 10) == Ok("0")
  assert to_base(0, 16) == Ok("0")
  assert to_base(0, 36) == Ok("0")
  assert to_base(1, 2) == Ok("1")
  assert to_base(1, 8) == Ok("1")
  assert to_base(1, 10) == Ok("1")
  assert to_base(1, 16) == Ok("1")
  assert to_base(1, 36) == Ok("1")
  assert to_base(239, 2) == Ok("11101111")
  assert to_base(239, 8) == Ok("357")
  assert to_base(239, 10) == Ok("239")
  assert to_base(239, 16) == Ok("ef")
  assert to_base(239, 36) == Ok("6n")
  assert to_base(255, 2) == Ok("11111111")
  assert to_base(255, 8) == Ok("377")
  assert to_base(255, 10) == Ok("255")
  assert to_base(255, 16) == Ok("ff")
  assert to_base(255, 36) == Ok("73")
  assert to_base(max_value, 0) == Err(Nil)
  assert to_base(max_value, -16) == Err(Nil)
  assert to_base(min_value, 37) == Err(Nil)
}

/// Returns `n` in decimal. It makes `U8` satisfy `Show`.
@external(native, "cheby_u8_show")
@external(js, "./u8.mjs", "show")
pub fn show(n: U8) -> String

// Comparison

/// Orders two `U8` values. It makes `U8` satisfy `Compare`.
pub fn compare(a: U8, b: U8) -> Order {
  case {
    a < b => Less
    a > b => Greater
    _ => Equal
  }
}

/// Returns the smaller of `a` and `b`, and `a` when they are `Equal`.
pub fn min(a: U8, b: U8) -> U8 {
  case {
    b < a => b
    _ => a
  }
}

/// Returns the larger of `a` and `b`, and `a` when they are `Equal`.
pub fn max(a: U8, b: U8) -> U8 {
  case {
    b > a => b
    _ => a
  }
}

// Arithmetic

/// Returns `a + b`, and panics when the result does not fit. It makes `U8` satisfy `Add`.
pub fn add(a: U8, b: U8) -> U8 {
  a + b
}

/// Returns `a - b`, and panics when the result does not fit. It makes `U8` satisfy `Sub`.
pub fn sub(a: U8, b: U8) -> U8 {
  a - b
}

/// Returns `a * b`, and panics when the result does not fit. It makes `U8` satisfy `Mul`.
pub fn mul(a: U8, b: U8) -> U8 {
  a * b
}

/// Returns `a / b` toward zero, panicking like `/`. It makes `U8` satisfy `Div`.
pub fn div(a: U8, b: U8) -> U8 {
  a / b
}

/// Returns `a % b`, with the sign of `a`, and panics on a zero divisor.
pub fn rem(a: U8, b: U8) -> U8 {
  a % b
}

/// Returns `-n`, and panics when it does not fit. It makes `U8` satisfy `Neg`.
pub fn neg(n: U8) -> U8 {
  -n
}

/// Returns `n`, since `U8` has no negative values.
pub fn abs(n: U8) -> U8 {
  n
}

// Checked arithmetic

/// Returns `Ok(a + b)`, or `Err(Nil)` when the sum does not fit (D-309).
@external(native, "cheby_u8_checked_add")
@external(js, "./u8.mjs", "checked_add")
pub fn checked_add(a: U8, b: U8) -> Result<U8, Nil>

/// Returns `Ok(a - b)`, or `Err(Nil)` when the difference does not fit (D-309).
@external(native, "cheby_u8_checked_sub")
@external(js, "./u8.mjs", "checked_sub")
pub fn checked_sub(a: U8, b: U8) -> Result<U8, Nil>

/// Returns `Ok(a * b)`, or `Err(Nil)` when the product does not fit (D-309).
@external(native, "cheby_u8_checked_mul")
@external(js, "./u8.mjs", "checked_mul")
pub fn checked_mul(a: U8, b: U8) -> Result<U8, Nil>

/// Returns `Ok(a / b)`, or `Err(Nil)` for a zero divisor (D-356).
pub fn checked_div(a: U8, b: U8) -> Result<U8, Nil> {
  case b {
    0 => Err(Nil)
    _ => Ok(a / b)
  }
}

/// Returns `Ok(a % b)`, or `Err(Nil)` for a zero divisor (D-356).
pub fn checked_rem(a: U8, b: U8) -> Result<U8, Nil> {
  case b {
    0 => Err(Nil)
    _ => Ok(a % b)
  }
}

/// Returns `Ok(n)` for 0, the only value whose negation fits, and `Err(Nil)` otherwise (D-309).
pub fn checked_neg(n: U8) -> Result<U8, Nil> {
  case n {
    0 => Ok(n)
    _ => Err(Nil)
  }
}

// Wrapping arithmetic

/// Returns `a + b` modulo 2^8 (D-025).
@external(native, "cheby_u8_wrapping_add")
@external(js, "./u8.mjs", "wrapping_add")
pub fn wrapping_add(a: U8, b: U8) -> U8

/// Returns `a - b` modulo 2^8 (D-025).
@external(native, "cheby_u8_wrapping_sub")
@external(js, "./u8.mjs", "wrapping_sub")
pub fn wrapping_sub(a: U8, b: U8) -> U8

/// Returns `a * b` modulo 2^8 (D-025).
@external(native, "cheby_u8_wrapping_mul")
@external(js, "./u8.mjs", "wrapping_mul")
pub fn wrapping_mul(a: U8, b: U8) -> U8

/// Returns `-n` modulo 2^8 (D-025).
@external(native, "cheby_u8_wrapping_neg")
@external(js, "./u8.mjs", "wrapping_neg")
pub fn wrapping_neg(n: U8) -> U8

// Examples

test "the u8 range" {
  assert min_value == 0
  assert max_value == 255
}

test "conversions to u8" {
  assert from_u32(200) == Ok(200)
  assert wrapping_from_u32(0x1234) == 0x34
  assert from_int(256) == Err(Nil)
  assert from_i8(-1) == Err(Nil)
  assert wrapping_from_u64(0x0123_4567_89AB_CDEF) == 0xEF
  assert wrapping_from_int(-1) == max_value
  assert wrapping_from_i8(-128) == 128
  assert wrapping_from_int(200) == 200
}

test "u8 parses and shows decimal digits" {
  let small: U8 = 7
  assert parse("255") == Ok(255)
  assert parse("256") == Err(Nil)
  assert parse("-1") == Err(Nil)
  assert parse("-0") == Ok(0)
  assert parse_base("ff", 16) == Ok(255)
  assert show(255) == "255"
  assert "{small}" == "7"
  assert to_base(max_value, 16) == Ok("ff")
  assert to_base(min_value, 2) == Ok("0")
  assert to_base(35, 36) == Ok("z")
  assert to_base(max_value, 37) == Err(Nil)
  assert to_base(max_value, 1) == Err(Nil)
}

test "comparing u8 values" {
  assert compare(1, 2) == Less
  assert compare(3, 3) == Equal
  assert min(100, 7) == 7
  assert max(100, 7) == 100
}

test "u8 operators as functions" {
  assert add(200, 55) == 255
  assert sub(7, 2) == 5
  assert mul(15, 17) == 255
  assert div(7, 2) == 3
  assert rem(7, 2) == 1
  assert neg(0) == 0
  assert abs(7) == 7
}

test "u8 checked arithmetic reports overflow" {
  assert checked_add(200, 55) == Ok(255)
  assert checked_add(max_value, 1) == Err(Nil)
  assert checked_sub(0, 1) == Err(Nil)
  assert checked_mul(max_value, 2) == Err(Nil)
  assert checked_div(7, 0) == Err(Nil)
  assert checked_rem(7, 2) == Ok(1)
  assert checked_neg(0) == Ok(0)
  assert checked_neg(1) == Err(Nil)
}

test "u8 wrapping arithmetic wraps around" {
  assert wrapping_add(max_value, 1) == 0
  assert wrapping_sub(0, 1) == max_value
  assert wrapping_mul(max_value, 2) == max_value - 1
  assert wrapping_neg(1) == max_value
}

// Puzzle helpers. They sit at the end of the file, so no std location that
// a golden pins moves (D-1603).

/// Returns the greatest common divisor of `a` and `b`, and `0` for
/// `gcd(0, 0)` (D-1606).
pub fn gcd(a: U8, b: U8) -> U8 {
  case b {
    0 => a
    _ => gcd(b, a % b)
  }
}

/// Returns the least common multiple of `a` and `b`, and `0` when either
/// is `0` (D-1606). It panics when the result does not fit.
pub fn lcm(a: U8, b: U8) -> U8 {
  case a, b {
    0, _ => 0
    _, 0 => 0
    _, _ => a / gcd(a, b) * b
  }
}

test "u8 gcd and lcm" {
  assert gcd(12, 18) == 6
  assert gcd(0, 5) == 5
  assert gcd(0, 0) == 0
  assert gcd(max_value, 5) == 5
  assert lcm(4, 6) == 12
  assert lcm(0, 6) == 0
  assert lcm(max_value, 1) == max_value
}
