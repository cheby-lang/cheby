//! Standard input, standard output, standard error, and reading and
//! writing whole files.
//!
//! Every function that can fail returns `Result<T, Error>`. `Error` is
//! opaque: callers ask the predicates, such as `is_not_found`, and handle
//! every other kind with a fallback arm (D-304, ADR-0051).
//!
//! The kernels report a failure as a pair of a kind code and the operating
//! system's message, and `Error` is built from it here, so its
//! representation stays private to this module (D-484).

import std::bytes

// Errors

/// An input or output failure. Its kind, and the operating system's
/// message for a kind without a predicate (D-345). Equality, hashing and
/// debug printing go through `equal`, `hash` and `debug_error` (D-342, D-368).
@std_hooks(equal, hash, debug_error)
pub type Error {
  kind: Kind,
  message: String,
}

/// The kinds of failure: one per predicate, and every other kind (D-367,
/// D-981).
type Kind {
  NotFound,
  PermissionDenied,
  InvalidData,
  ConnectionRefused,
  ConnectionReset,
  AddressInUse,
  HostNotFound,
  Closed,
  InvalidInput,
  AlreadyExists,
  IsADirectory,
  NotADirectory,
  DirectoryNotEmpty,
  BrokenPipe,
  Other,
}

/// The `Error` for the kernels' pair: `1` not found, `2` permission
/// denied, `3` invalid UTF-8, `4` already exists, `5` is a directory, `6`
/// not a directory, `7` directory not empty, `8` connection refused, `9`
/// connection reset, `10` address in use, `11` host not found, `12`
/// closed, `13` invalid input, `14` broken pipe, anything else another kind with the
/// operating system's message. A kind with a predicate drops the message,
/// so its text is the same on every platform (D-345, D-981).
fn from_os(code: Int, message: String) -> Error {
  case code {
    1 => Error { kind: NotFound, message: "" }
    2 => Error { kind: PermissionDenied, message: "" }
    3 => Error { kind: InvalidData, message: "" }
    4 => Error { kind: AlreadyExists, message: "" }
    5 => Error { kind: IsADirectory, message: "" }
    6 => Error { kind: NotADirectory, message: "" }
    7 => Error { kind: DirectoryNotEmpty, message: "" }
    8 => Error { kind: ConnectionRefused, message: "" }
    9 => Error { kind: ConnectionReset, message: "" }
    10 => Error { kind: AddressInUse, message: "" }
    11 => Error { kind: HostNotFound, message: "" }
    12 => Error { kind: Closed, message: "" }
    13 => Error { kind: InvalidInput, message: "" }
    14 => Error { kind: BrokenPipe, message: "" }
    _ => Error { kind: Other, message }
  }
}

/// A kernel's outcome with its failure turned into an `Error`.
fn lift<T>(outcome: Result<T, (Int, String)>) -> Result<T, Error> {
  case outcome {
    Ok(value) => Ok(value)
    Err((code, message)) => Err(from_os(code, message))
  }
}

/// What two equal errors share: the kind, and the message for a kind
/// without a predicate (D-368). The runtime hashes this value.
fn hash(error: Error) -> (Int, String) {
  case error.kind {
    NotFound => (1, "")
    PermissionDenied => (2, "")
    InvalidData => (3, "")
    AlreadyExists => (4, "")
    IsADirectory => (5, "")
    NotADirectory => (6, "")
    DirectoryNotEmpty => (7, "")
    ConnectionRefused => (8, "")
    ConnectionReset => (9, "")
    AddressInUse => (10, "")
    HostNotFound => (11, "")
    Closed => (12, "")
    InvalidInput => (13, "")
    BrokenPipe => (14, "")
    Other => (0, error.message)
  }
}

/// Whether two errors are `==`: the same kind and, for a kind without a
/// predicate, the same message (D-368).
fn equal(a: Error, b: Error) -> Bool {
  hash(a) == hash(b)
}

/// The debug text of an error, the same as its `show` text (§3.13).
fn debug_error(error: Error) -> String {
  show(error)
}

// Standard output and standard error

/// Writes `text` to standard output, with no line ending.
@external(native, "cheby_io_print")
@external(js, "./io.mjs", "print")
pub fn print(text: String)

/// Writes `text` and a line ending to standard output.
@external(native, "cheby_io_println")
@external(js, "./io.mjs", "println")
pub fn println(text: String)

/// Writes `text` to standard error, with no line ending.
@external(native, "cheby_io_eprint")
@external(js, "./io.mjs", "eprint")
pub fn eprint(text: String)

/// Writes `text` and a line ending to standard error.
@external(native, "cheby_io_eprintln")
@external(js, "./io.mjs", "eprintln")
pub fn eprintln(text: String)

/// Writes `text` to standard output, with no line ending, and reports a
/// failure instead of ending the program (D-306, D-365).
pub fn write_stdout(text: String) -> Result<Nil, Error> {
  lift(sys_write_stdout(text))
}

/// Writes `text` to standard error, with no line ending, and reports a
/// failure instead of ending the program (D-306).
pub fn write_stderr(text: String) -> Result<Nil, Error> {
  lift(sys_write_stderr(text))
}

// Standard input

/// Reads the next line from standard input, without its line ending, or
/// `None` at the end of input (D-305).
pub fn read_line() -> Result<Option<String>, Error> {
  // No call may follow the kernel on success: a call's entry check would
  // deliver a pending cancellation and drop the line just taken from
  // standard input's reader (D-1065).
  case sys_read_line() {
    Ok(line) => Ok(line)
    Err(failure) => lift(Err(failure))
  }
}

// Files

/// Reads the whole file at `path` as UTF-8 text (D-311, D-366).
pub fn read_file(path: String) -> Result<String, Error> {
  lift(sys_read_file(path))
}

test "read_file reports a missing file" {
  let assert Err(reason) = read_file("no/such/directory/file.txt")
  assert is_not_found(reason)
}

/// Reads the whole file at `path` as raw bytes (D-311).
pub fn read_file_bytes(path: String) -> Result<bytes::Bytes, Error> {
  lift(sys_read_file_bytes(path))
}

test "read_file_bytes reports a missing file" {
  let assert Err(reason) = read_file_bytes("no/such/directory/file.bin")
  assert is_not_found(reason)
}

/// Writes `text` as UTF-8 to the file at `path`, creating or replacing it
/// (D-328).
pub fn write_file(path: String, text: String) -> Result<Nil, Error> {
  lift(sys_write_file(path, text))
}

test "write_file needs the directory to exist" {
  let assert Err(reason) = write_file("no/such/directory/out.txt", "hello")
  assert is_not_found(reason)
}

/// Writes `data` to the file at `path` unchanged, creating or replacing it
/// (D-328).
pub fn write_file_bytes(path: String, data: bytes::Bytes) -> Result<Nil, Error> {
  lift(sys_write_file_bytes(path, data))
}

test "write_file_bytes needs the directory to exist" {
  let assert Err(reason) = write_file_bytes("no/such/directory/out.bin", bytes::from_list([0x00]))
  assert is_not_found(reason)
}

// Errors

/// Tells whether `error` means that a file or a directory on its path does
/// not exist.
pub fn is_not_found(error: Error) -> Bool {
  case error.kind {
    NotFound => True
    _ => False
  }
}

test "a missing file is not found" {
  let assert Err(reason) = read_file("no/such/directory/file.txt")
  assert is_not_found(reason)
  assert !is_permission_denied(reason)
  assert !is_invalid_data(reason)
}

/// Tells whether `error` means that the operating system refused the
/// program access to a file or a directory.
pub fn is_permission_denied(error: Error) -> Bool {
  case error.kind {
    PermissionDenied => True
    _ => False
  }
}

/// Tells whether `error` means that text read from the operating system
/// was not valid UTF-8 (D-311).
pub fn is_invalid_data(error: Error) -> Bool {
  case error.kind {
    InvalidData => True
    _ => False
  }
}

/// Tells whether `error` means that something already exists at a path
/// where a directory, or a file opened with `file::create_new`, was to be
/// created (D-981, D-1066).
pub fn is_already_exists(error: Error) -> Bool {
  case error.kind {
    AlreadyExists => True
    _ => False
  }
}

/// Tells whether `error` means that a path names a directory where a file
/// was expected (D-981).
pub fn is_a_directory(error: Error) -> Bool {
  case error.kind {
    IsADirectory => True
    _ => False
  }
}

/// Tells whether `error` means that a path names something other than a
/// directory where a directory was expected, including a path that goes
/// through a file (D-981).
pub fn is_not_a_directory(error: Error) -> Bool {
  case error.kind {
    NotADirectory => True
    _ => False
  }
}

/// Tells whether `error` means that a directory could not be removed
/// because it has entries (D-981).
pub fn is_directory_not_empty(error: Error) -> Bool {
  case error.kind {
    DirectoryNotEmpty => True
    _ => False
  }
}

test "the file kinds have their predicates and fixed texts" {
  let kinds = [
    (4, "already exists"),
    (5, "is a directory"),
    (6, "not a directory"),
    (7, "directory not empty"),
  ]
  fn check(rest: List<(Int, String)>) {
    case rest {
      [] => Nil
      [(code, text), ..tail] => {
        let error = from_os(code, "the system's own words")
        assert show(error) == text
        assert "{error:?}" == text
        assert error == from_os(code, "other words")
        assert error != from_os(0, "the system's own words")
        assert is_already_exists(error) == (code == 4)
        assert is_a_directory(error) == (code == 5)
        assert is_not_a_directory(error) == (code == 6)
        assert is_directory_not_empty(error) == (code == 7)
        assert !is_not_found(error)
        assert !is_invalid_input(error)
        check(tail)
      }
    }
  }
  check(kinds)
}

/// Tells whether `error` means that nothing listens at the address a
/// connection was made to (D-981).
pub fn is_connection_refused(error: Error) -> Bool {
  case error.kind {
    ConnectionRefused => True
    _ => False
  }
}

/// Tells whether `error` means that the peer of a connection reset it,
/// aborted it or went away while it was written to (D-981).
pub fn is_connection_reset(error: Error) -> Bool {
  case error.kind {
    ConnectionReset => True
    _ => False
  }
}

/// Tells whether `error` means that another socket already listens on an
/// address and port (D-981).
pub fn is_address_in_use(error: Error) -> Bool {
  case error.kind {
    AddressInUse => True
    _ => False
  }
}

/// Tells whether `error` means that a host name could not be resolved.
/// Every failure of name lookup is this one kind (D-981).
pub fn is_host_not_found(error: Error) -> Bool {
  case error.kind {
    HostNotFound => True
    _ => False
  }
}

/// Tells whether `error` means that a handle was used after it was
/// closed, or was closed while a fiber waited on it (D-981, D-1063).
pub fn is_closed(error: Error) -> Bool {
  case error.kind {
    Closed => True
    _ => False
  }
}

/// Tells whether `error` means that an argument could not be used: a path
/// that contains U+0000, a port outside 0 to 65535, or a file handle used
/// in a mode it was not opened for (D-981).
pub fn is_invalid_input(error: Error) -> Bool {
  case error.kind {
    InvalidInput => True
    _ => False
  }
}

/// Tells whether `error` means that a write went to a pipe whose reading end is closed: a child
/// that closed its standard input or exited (D-1915).
pub fn is_broken_pipe(error: Error) -> Bool {
  case error.kind {
    BrokenPipe => True
    _ => False
  }
}

test "the broken pipe kind has its predicate and fixed text" {
  let error = from_os(14, "the system's own words")
  assert show(error) == "broken pipe"
  assert "{error:?}" == "broken pipe"
  assert error == from_os(14, "other words")
  assert error != from_os(0, "the system's own words")
  assert is_broken_pipe(error)
  assert !is_closed(error)
  assert !is_connection_reset(error)
  assert !is_broken_pipe(from_os(9, ""))
}

test "the network kinds have their predicates and fixed texts" {
  let kinds = [
    (8, "connection refused"),
    (9, "connection reset"),
    (10, "address in use"),
    (11, "host not found"),
    (12, "closed"),
    (13, "invalid input"),
  ]
  fn check(rest: List<(Int, String)>) {
    case rest {
      [] => Nil
      [(code, text), ..tail] => {
        let error = from_os(code, "the system's own words")
        assert show(error) == text
        assert "{error:?}" == text
        assert error == from_os(code, "other words")
        assert error != from_os(0, "the system's own words")
        assert is_connection_refused(error) == (code == 8)
        assert is_connection_reset(error) == (code == 9)
        assert is_address_in_use(error) == (code == 10)
        assert is_host_not_found(error) == (code == 11)
        assert is_closed(error) == (code == 12)
        assert is_invalid_input(error) == (code == 13)
        assert !is_not_found(error)
        check(tail)
      }
    }
  }
  check(kinds)
}

/// Returns the text of `error`: a fixed message for each kind with a
/// predicate, and the operating system's message otherwise (D-345,
/// D-981). It makes `Error` satisfy `Show`.
pub fn show(error: Error) -> String {
  case error.kind {
    NotFound => "not found"
    PermissionDenied => "permission denied"
    InvalidData => "invalid UTF-8"
    AlreadyExists => "already exists"
    IsADirectory => "is a directory"
    NotADirectory => "not a directory"
    DirectoryNotEmpty => "directory not empty"
    ConnectionRefused => "connection refused"
    ConnectionReset => "connection reset"
    AddressInUse => "address in use"
    HostNotFound => "host not found"
    Closed => "closed"
    InvalidInput => "invalid input"
    BrokenPipe => "broken pipe"
    Other => error.message
  }
}

test "an io error shows a fixed message" {
  let assert Err(reason) = read_file("no/such/directory/file.txt")
  assert show(reason) == "not found"
  assert "{reason}" == "not found"
  assert "{reason:?}" == "not found"
}

// Streams (D-1072, ADR-0070). D-1297: they sit after `show` so that no std location before
// it moves.

/// A stream that bytes are read from. `read_bytes(source, limit)` returns the next bytes of the
/// stream, at most `limit` of them, or `Ok(None)` at its end. `file::File`, `net::Connection` and
/// the standard-stream handles satisfy it through their modules' `read_bytes` (D-1062, D-1071).
pub interface Source {
  fn read_bytes(Self, Int) -> Result<Option<bytes::Bytes>, Error>
}

/// A stream that bytes are written to. `write_bytes(sink, data)` writes all of `data`.
/// `file::File`, `net::Connection` and the standard-stream handles satisfy it through their
/// modules' `write_bytes` (D-1062, D-1071).
pub interface Sink {
  fn write_bytes(Self, bytes::Bytes) -> Result<Nil, Error>
}

/// Reads blocks of at most 64 KiB from `source` until its end, writes each one to `sink`, and
/// returns the number of bytes copied (D-1072). It stops at the first `Err` of either side and
/// returns it; what was written before stays written.
pub fn copy<S: Source, K: Sink>(source: S, sink: K) -> Result<Int, Error> {
  copy_from(source, sink, 0)
}

/// `copy`'s loop, with the bytes copied so far. It reads at most 64 KiB at once (D-1072); the size
/// is a literal, so that `std::io` declares no constant.
fn copy_from<S: Source, K: Sink>(source: S, sink: K, copied: Int) -> Result<Int, Error> {
  case Source::read_bytes(source, 65_536) {
    Err(reason) => Err(reason)
    Ok(None) => Ok(copied)
    Ok(Some(block)) => case Sink::write_bytes(sink, block) {
      Err(reason) => Err(reason)
      Ok(_) => copy_from(source, sink, copied + bytes_length(block))
    }
  }
}

/// Returns an `Error` whose text is `message`, of the kind that the operating system's other
/// failures have, so no predicate holds for it (D-342, D-981, D-1072).
pub fn other(message: String) -> Error {
  Error { kind: Other, message }
}

test "other builds an error with its own text" {
  let reason = other("upstream closed")
  assert "{reason}" == "upstream closed"
  assert !is_not_found(reason)
  assert reason == other("upstream closed")
}

// Kernels: each reports a failure as a kind code and the operating
// system's message (see `from_os`).

/// Writes to standard output through its buffer, then flushes it.
@external(native, "cheby_io_sys_write_stdout")
@external(js, "./io.mjs", "sys_write_stdout")
fn sys_write_stdout(text: String) -> Result<Nil, (Int, String)>

/// Writes to standard error.
@external(native, "cheby_io_sys_write_stderr")
@external(js, "./io.mjs", "sys_write_stderr")
fn sys_write_stderr(text: String) -> Result<Nil, (Int, String)>

/// Flushes standard output, then reads one line from standard input.
@std_context
@external(native, "cheby_io_sys_read_line")
@external(js, "./io.mjs", "sys_read_line")
fn sys_read_line() -> Result<Option<String>, (Int, String)>

/// Reads a whole file as UTF-8 text.
@std_context
@external(native, "cheby_io_sys_read_file")
@external(js, "./io.mjs", "sys_read_file")
fn sys_read_file(path: String) -> Result<String, (Int, String)>

/// Reads a whole file as bytes.
@std_context
@external(native, "cheby_io_sys_read_file_bytes")
@external(js, "./io.mjs", "sys_read_file_bytes")
fn sys_read_file_bytes(path: String) -> Result<bytes::Bytes, (Int, String)>

/// Writes a whole file from UTF-8 text.
@std_context
@external(native, "cheby_io_sys_write_file")
@external(js, "./io.mjs", "sys_write_file")
fn sys_write_file(path: String, text: String) -> Result<Nil, (Int, String)>

/// Writes a whole file from bytes.
@std_context
@external(native, "cheby_io_sys_write_file_bytes")
@external(js, "./io.mjs", "sys_write_file_bytes")
fn sys_write_file_bytes(path: String, data: bytes::Bytes) -> Result<Nil, (Int, String)>

/// `bytes::length`'s own kernel, for `copy`'s count. A call of `bytes::length` would make every
/// program that uses `std::io` compile all of `std::bytes` with it. D-1297.
@external(native, "cheby_bytes_length")
@external(js, "./bytes.mjs", "length")
priv fn bytes_length(data: bytes::Bytes) -> Int

// Debugging

/// Writes the debug text of `value` (§3.13) and a line ending to standard
/// error, then returns `value`, so a call can wrap any expression or stand
/// in a pipeline. It sits at the end of the file, so no std location that a
/// golden pins moves (D-1603).
pub fn debug<T>(value: T) -> T {
  eprintln("{value:?}")
  value
}

/// Writes `label`, `: `, the debug text of `value` and a line ending to
/// standard error, then returns `value` (D-1603).
pub fn debug_as<T>(value: T, label: String) -> T {
  eprintln(string_add(label, ": {value:?}"))
  value
}

/// `string::add`'s own kernel, for `debug_as`'s line. A call of `string::add`, or `{label}`, would
/// make every program that uses `std::io` compile all of `std::string` and `std::bytes` with it
/// (D-1297, D-1603).
@external(native, "cheby_string_add")
@external(js, "./string.mjs", "add")
priv fn string_add(a: String, b: String) -> String
