//! The built-in `I8`, a signed 8-bit integer: constants, conversions,
//! parsing and text, comparison, and checked and wrapping arithmetic
//! (the integer families of `docs/stdlib/README.md`, D-350).
//!
//! `I8` itself is a builtin item whose home module is this one (D-447).

import std::int

// Constants

/// The smallest `I8`.
pub const min_value: I8 = -128

/// The largest `I8`.
pub const max_value: I8 = 127

// Conversions

/// Returns `n` as an `I8`, or `Err(Nil)` when it does not fit.
@external(native, "cheby_i8_from_int")
@external(js, "./i8.mjs", "from_int")
pub fn from_int(n: Int) -> Result<I8, Nil>

/// Returns `n` as an `I8`, or `Err(Nil)` when it does not fit.
@external(native, "cheby_i8_from_i16")
@external(js, "./i8.mjs", "from_i16")
pub fn from_i16(n: I16) -> Result<I8, Nil>

/// Returns `n` as an `I8`, or `Err(Nil)` when it does not fit.
@external(native, "cheby_i8_from_i32")
@external(js, "./i8.mjs", "from_i32")
pub fn from_i32(n: I32) -> Result<I8, Nil>

/// Returns `n` as an `I8`, or `Err(Nil)` when it does not fit.
@external(native, "cheby_i8_from_i64")
@external(js, "./i8.mjs", "from_i64")
pub fn from_i64(n: I64) -> Result<I8, Nil>

/// Returns `n` as an `I8`, or `Err(Nil)` when it does not fit.
@external(native, "cheby_i8_from_u8")
@external(js, "./i8.mjs", "from_u8")
pub fn from_u8(n: U8) -> Result<I8, Nil>

/// Returns `n` as an `I8`, or `Err(Nil)` when it does not fit.
@external(native, "cheby_i8_from_u16")
@external(js, "./i8.mjs", "from_u16")
pub fn from_u16(n: U16) -> Result<I8, Nil>

/// Returns `n` as an `I8`, or `Err(Nil)` when it does not fit.
@external(native, "cheby_i8_from_u32")
@external(js, "./i8.mjs", "from_u32")
pub fn from_u32(n: U32) -> Result<I8, Nil>

/// Returns `n` as an `I8`, or `Err(Nil)` when it does not fit.
@external(native, "cheby_i8_from_u64")
@external(js, "./i8.mjs", "from_u64")
pub fn from_u64(n: U64) -> Result<I8, Nil>

/// Keeps the low 8 bits of `n`'s two's-complement value and reads them as an `I8` (D-1091).
pub fn wrapping_from_int(n: Int) -> I8 {
  let low = n & 0xFF
  case low < 0x80 {
    True => {
      let assert Ok(value) = from_int(low)
      value
    }
    False => {
      // `0xFF - low` fits, and minus it minus 1 is `low` - 2^8.
      let assert Ok(complement) = from_int(0xFF - low)
      -complement - 1
    }
  }
}

/// Keeps the low 8 bits of `n`'s two's-complement value and reads them as an `I8` (D-1091).
pub fn wrapping_from_i16(n: I16) -> I8 {
  let low = n & 0xFF
  case low < 0x80 {
    True => {
      let assert Ok(value) = from_i16(low)
      value
    }
    False => {
      // `0xFF - low` fits, and minus it minus 1 is `low` - 2^8.
      let assert Ok(complement) = from_i16(0xFF - low)
      -complement - 1
    }
  }
}

/// Keeps the low 8 bits of `n`'s two's-complement value and reads them as an `I8` (D-1091).
pub fn wrapping_from_i32(n: I32) -> I8 {
  let low = n & 0xFF
  case low < 0x80 {
    True => {
      let assert Ok(value) = from_i32(low)
      value
    }
    False => {
      // `0xFF - low` fits, and minus it minus 1 is `low` - 2^8.
      let assert Ok(complement) = from_i32(0xFF - low)
      -complement - 1
    }
  }
}

/// Keeps the low 8 bits of `n`'s two's-complement value and reads them as an `I8` (D-1091).
pub fn wrapping_from_i64(n: I64) -> I8 {
  let low = n & 0xFF
  case low < 0x80 {
    True => {
      let assert Ok(value) = from_i64(low)
      value
    }
    False => {
      // `0xFF - low` fits, and minus it minus 1 is `low` - 2^8.
      let assert Ok(complement) = from_i64(0xFF - low)
      -complement - 1
    }
  }
}

/// Keeps the low 8 bits of `n`'s two's-complement value and reads them as an `I8` (D-1091).
pub fn wrapping_from_u8(n: U8) -> I8 {
  case n < 0x80 {
    True => {
      let assert Ok(value) = from_u8(n)
      value
    }
    False => {
      // `0xFF - n` fits, and minus it minus 1 is `n` - 2^8.
      let assert Ok(complement) = from_u8(0xFF - n)
      -complement - 1
    }
  }
}

/// Keeps the low 8 bits of `n`'s two's-complement value and reads them as an `I8` (D-1091).
pub fn wrapping_from_u16(n: U16) -> I8 {
  let low = n & 0xFF
  case low < 0x80 {
    True => {
      let assert Ok(value) = from_u16(low)
      value
    }
    False => {
      // `0xFF - low` fits, and minus it minus 1 is `low` - 2^8.
      let assert Ok(complement) = from_u16(0xFF - low)
      -complement - 1
    }
  }
}

/// Keeps the low 8 bits of `n`'s two's-complement value and reads them as an `I8` (D-1091).
pub fn wrapping_from_u32(n: U32) -> I8 {
  let low = n & 0xFF
  case low < 0x80 {
    True => {
      let assert Ok(value) = from_u32(low)
      value
    }
    False => {
      // `0xFF - low` fits, and minus it minus 1 is `low` - 2^8.
      let assert Ok(complement) = from_u32(0xFF - low)
      -complement - 1
    }
  }
}

/// Keeps the low 8 bits of `n`'s two's-complement value and reads them as an `I8` (D-1091).
pub fn wrapping_from_u64(n: U64) -> I8 {
  let low = n & 0xFF
  case low < 0x80 {
    True => {
      let assert Ok(value) = from_u64(low)
      value
    }
    False => {
      // `0xFF - low` fits, and minus it minus 1 is `low` - 2^8.
      let assert Ok(complement) = from_u64(0xFF - low)
      -complement - 1
    }
  }
}

test "wrapping_from keeps the low 8 bits of every source" {
  assert wrapping_from_int(-129) == 127
  assert wrapping_from_int(-128) == -128
  assert wrapping_from_int(-1) == -1
  assert wrapping_from_int(0) == 0
  assert wrapping_from_int(1) == 1
  assert wrapping_from_int(127) == 127
  assert wrapping_from_int(128) == -128
  assert wrapping_from_i16(-32_768) == 0
  assert wrapping_from_i16(-12_817) == -17
  assert wrapping_from_i16(-129) == 127
  assert wrapping_from_i16(-128) == -128
  assert wrapping_from_i16(-1) == -1
  assert wrapping_from_i16(0) == 0
  assert wrapping_from_i16(1) == 1
  assert wrapping_from_i16(127) == 127
  assert wrapping_from_i16(128) == -128
  assert wrapping_from_i16(12_817) == 17
  assert wrapping_from_i16(32_767) == -1
  assert wrapping_from_i32(-2_147_483_648) == 0
  assert wrapping_from_i32(-1_985_229_329) == -17
  assert wrapping_from_i32(-129) == 127
  assert wrapping_from_i32(-128) == -128
  assert wrapping_from_i32(-1) == -1
  assert wrapping_from_i32(0) == 0
  assert wrapping_from_i32(1) == 1
  assert wrapping_from_i32(127) == 127
  assert wrapping_from_i32(128) == -128
  assert wrapping_from_i32(1_985_229_329) == 17
  assert wrapping_from_i32(2_147_483_647) == -1
  assert wrapping_from_i64(-9_223_372_036_854_775_808) == 0
  assert wrapping_from_i64(-81_985_529_216_486_895) == 17
  assert wrapping_from_i64(-129) == 127
  assert wrapping_from_i64(-128) == -128
  assert wrapping_from_i64(-1) == -1
  assert wrapping_from_i64(0) == 0
  assert wrapping_from_i64(1) == 1
  assert wrapping_from_i64(127) == 127
  assert wrapping_from_i64(128) == -128
  assert wrapping_from_i64(81_985_529_216_486_895) == -17
  assert wrapping_from_i64(9_223_372_036_854_775_807) == -1
  assert wrapping_from_u8(0) == 0
  assert wrapping_from_u8(1) == 1
  assert wrapping_from_u8(127) == 127
  assert wrapping_from_u8(128) == -128
  assert wrapping_from_u8(239) == -17
  assert wrapping_from_u8(255) == -1
  assert wrapping_from_u16(0) == 0
  assert wrapping_from_u16(1) == 1
  assert wrapping_from_u16(127) == 127
  assert wrapping_from_u16(128) == -128
  assert wrapping_from_u16(52_719) == -17
  assert wrapping_from_u16(65_535) == -1
  assert wrapping_from_u32(0) == 0
  assert wrapping_from_u32(1) == 1
  assert wrapping_from_u32(127) == 127
  assert wrapping_from_u32(128) == -128
  assert wrapping_from_u32(2_309_737_967) == -17
  assert wrapping_from_u32(4_294_967_295) == -1
  assert wrapping_from_u64(0) == 0
  assert wrapping_from_u64(1) == 1
  assert wrapping_from_u64(127) == 127
  assert wrapping_from_u64(128) == -128
  assert wrapping_from_u64(81_985_529_216_486_895) == -17
  assert wrapping_from_u64(18_446_744_073_709_551_615) == -1
}

@target(native)
test "wrapping_from_int keeps the low 8 bits of every Int" {
  assert wrapping_from_int(-9_223_372_036_854_775_808) == 0
  assert wrapping_from_int(-81_985_529_216_486_895) == 17
  assert wrapping_from_int(81_985_529_216_486_895) == -17
  assert wrapping_from_int(9_223_372_036_854_775_807) == -1
}

// Parsing and text

/// Reads an `I8` written as an optional `-` and ASCII decimal digits (D-312).
@external(native, "cheby_i8_parse")
@external(js, "./i8.mjs", "parse")
pub fn parse(text: String) -> Result<I8, Nil>

/// Reads an `I8` written in `base`, from 2 to 36, as an optional `-` and digits.
@external(native, "cheby_i8_parse_base")
@external(js, "./i8.mjs", "parse_base")
pub fn parse_base(text: String, base: Int) -> Result<I8, Nil>

/// Returns `n` written in `base`, from 2 to 36, in lowercase digits (D-390, D-1090).
pub fn to_base(n: I8, base: Int) -> Result<String, Nil> {
  int::to_base(int::from_i8(n), base)
}

test "to_base writes every I8 in every base" {
  assert to_base(-128, 2) == Ok("-10000000")
  assert to_base(-128, 8) == Ok("-200")
  assert to_base(-128, 10) == Ok("-128")
  assert to_base(-128, 16) == Ok("-80")
  assert to_base(-128, 36) == Ok("-3k")
  assert to_base(-127, 2) == Ok("-1111111")
  assert to_base(-127, 8) == Ok("-177")
  assert to_base(-127, 10) == Ok("-127")
  assert to_base(-127, 16) == Ok("-7f")
  assert to_base(-127, 36) == Ok("-3j")
  assert to_base(-17, 2) == Ok("-10001")
  assert to_base(-17, 8) == Ok("-21")
  assert to_base(-17, 10) == Ok("-17")
  assert to_base(-17, 16) == Ok("-11")
  assert to_base(-17, 36) == Ok("-h")
  assert to_base(-1, 2) == Ok("-1")
  assert to_base(-1, 8) == Ok("-1")
  assert to_base(-1, 10) == Ok("-1")
  assert to_base(-1, 16) == Ok("-1")
  assert to_base(-1, 36) == Ok("-1")
  assert to_base(0, 2) == Ok("0")
  assert to_base(0, 8) == Ok("0")
  assert to_base(0, 10) == Ok("0")
  assert to_base(0, 16) == Ok("0")
  assert to_base(0, 36) == Ok("0")
  assert to_base(1, 2) == Ok("1")
  assert to_base(1, 8) == Ok("1")
  assert to_base(1, 10) == Ok("1")
  assert to_base(1, 16) == Ok("1")
  assert to_base(1, 36) == Ok("1")
  assert to_base(127, 2) == Ok("1111111")
  assert to_base(127, 8) == Ok("177")
  assert to_base(127, 10) == Ok("127")
  assert to_base(127, 16) == Ok("7f")
  assert to_base(127, 36) == Ok("3j")
  assert to_base(max_value, 0) == Err(Nil)
  assert to_base(max_value, -16) == Err(Nil)
  assert to_base(min_value, 37) == Err(Nil)
}

/// Returns `n` in decimal. It makes `I8` satisfy `Show`.
@external(native, "cheby_i8_show")
@external(js, "./i8.mjs", "show")
pub fn show(n: I8) -> String

// Comparison

/// Orders two `I8` values. It makes `I8` satisfy `Compare`.
pub fn compare(a: I8, b: I8) -> Order {
  case {
    a < b => Less
    a > b => Greater
    _ => Equal
  }
}

/// Returns the smaller of `a` and `b`, and `a` when they are `Equal`.
pub fn min(a: I8, b: I8) -> I8 {
  case {
    b < a => b
    _ => a
  }
}

/// Returns the larger of `a` and `b`, and `a` when they are `Equal`.
pub fn max(a: I8, b: I8) -> I8 {
  case {
    b > a => b
    _ => a
  }
}

// Arithmetic

/// Returns `a + b`, and panics when the result does not fit. It makes `I8` satisfy `Add`.
pub fn add(a: I8, b: I8) -> I8 {
  a + b
}

/// Returns `a - b`, and panics when the result does not fit. It makes `I8` satisfy `Sub`.
pub fn sub(a: I8, b: I8) -> I8 {
  a - b
}

/// Returns `a * b`, and panics when the result does not fit. It makes `I8` satisfy `Mul`.
pub fn mul(a: I8, b: I8) -> I8 {
  a * b
}

/// Returns `a / b` toward zero, panicking like `/`. It makes `I8` satisfy `Div`.
pub fn div(a: I8, b: I8) -> I8 {
  a / b
}

/// Returns `a % b`, with the sign of `a`, and panics on a zero divisor.
pub fn rem(a: I8, b: I8) -> I8 {
  a % b
}

/// Returns `-n`, and panics when it does not fit. It makes `I8` satisfy `Neg`.
pub fn neg(n: I8) -> I8 {
  -n
}

/// Returns `n` without its sign, and panics for `min_value`, like `neg`.
pub fn abs(n: I8) -> I8 {
  case {
    n < 0 => -n
    _ => n
  }
}

// Checked arithmetic

/// Returns `Ok(a + b)`, or `Err(Nil)` when the sum does not fit (D-309).
@external(native, "cheby_i8_checked_add")
@external(js, "./i8.mjs", "checked_add")
pub fn checked_add(a: I8, b: I8) -> Result<I8, Nil>

/// Returns `Ok(a - b)`, or `Err(Nil)` when the difference does not fit (D-309).
@external(native, "cheby_i8_checked_sub")
@external(js, "./i8.mjs", "checked_sub")
pub fn checked_sub(a: I8, b: I8) -> Result<I8, Nil>

/// Returns `Ok(a * b)`, or `Err(Nil)` when the product does not fit (D-309).
@external(native, "cheby_i8_checked_mul")
@external(js, "./i8.mjs", "checked_mul")
pub fn checked_mul(a: I8, b: I8) -> Result<I8, Nil>

/// Returns `Ok(a / b)`, or `Err(Nil)` for a zero divisor and for `min_value / -1` (D-356).
pub fn checked_div(a: I8, b: I8) -> Result<I8, Nil> {
  // Dividing by -1 overflows exactly when negating does.
  case b {
    0 => Err(Nil)
    -1 => checked_neg(a)
    _ => Ok(a / b)
  }
}

/// Returns `Ok(a % b)`, or `Err(Nil)` for a zero divisor (D-356).
pub fn checked_rem(a: I8, b: I8) -> Result<I8, Nil> {
  case b {
    0 => Err(Nil)
    _ => Ok(a % b)
  }
}

/// Returns `Ok(-n)`, or `Err(Nil)` for `min_value` (D-309).
pub fn checked_neg(n: I8) -> Result<I8, Nil> {
  case {
    n == min_value => Err(Nil)
    _ => Ok(-n)
  }
}

// Wrapping arithmetic

/// Returns `a + b` modulo 2^8 (D-025).
@external(native, "cheby_i8_wrapping_add")
@external(js, "./i8.mjs", "wrapping_add")
pub fn wrapping_add(a: I8, b: I8) -> I8

/// Returns `a - b` modulo 2^8 (D-025).
@external(native, "cheby_i8_wrapping_sub")
@external(js, "./i8.mjs", "wrapping_sub")
pub fn wrapping_sub(a: I8, b: I8) -> I8

/// Returns `a * b` modulo 2^8 (D-025).
@external(native, "cheby_i8_wrapping_mul")
@external(js, "./i8.mjs", "wrapping_mul")
pub fn wrapping_mul(a: I8, b: I8) -> I8

/// Returns `-n` modulo 2^8 (D-025).
@external(native, "cheby_i8_wrapping_neg")
@external(js, "./i8.mjs", "wrapping_neg")
pub fn wrapping_neg(n: I8) -> I8

// Examples

test "the i8 range" {
  assert min_value == -128
  assert max_value == 127
}

test "conversions to i8" {
  assert from_int(-128) == Ok(-128)
  assert from_int(128) == Err(Nil)
  assert from_i32(-5) == Ok(-5)
  assert from_u8(200) == Err(Nil)
  assert wrapping_from_u64(0x0123_4567_89AB_CDEF) == -17
  assert wrapping_from_int(-1) == -1
  assert wrapping_from_u8(255) == -1
  assert wrapping_from_int(200) == -56
}

test "i8 parses and shows decimal digits" {
  let small: I8 = -5
  assert parse("-128") == Ok(-128)
  assert parse("128") == Err(Nil)
  assert parse("+1") == Err(Nil)
  assert parse_base("7f", 16) == Ok(127)
  assert show(-128) == "-128"
  assert "{small}" == "-5"
  assert to_base(max_value, 16) == Ok("7f")
  assert to_base(min_value, 2) == Ok("-10000000")
  assert to_base(35, 36) == Ok("z")
  assert to_base(max_value, 37) == Err(Nil)
  assert to_base(max_value, 1) == Err(Nil)
}

test "comparing i8 values" {
  assert compare(-1, 1) == Less
  assert compare(3, 3) == Equal
  assert min(-100, 7) == -100
  assert max(-100, 7) == 7
}

test "i8 operators as functions" {
  assert add(100, 27) == 127
  assert sub(-100, 28) == -128
  assert mul(-4, 5) == -20
  assert div(-7, 2) == -3
  assert rem(-7, 2) == -1
  assert neg(127) == -127
  assert abs(-127) == 127
}

test "i8 checked arithmetic reports overflow" {
  assert checked_add(100, 27) == Ok(127)
  assert checked_add(max_value, 1) == Err(Nil)
  assert checked_sub(min_value, 1) == Err(Nil)
  assert checked_mul(max_value, 2) == Err(Nil)
  assert checked_div(min_value, -1) == Err(Nil)
  assert checked_rem(7, 0) == Err(Nil)
  assert checked_neg(min_value) == Err(Nil)
}

test "i8 wrapping arithmetic wraps around" {
  assert wrapping_add(max_value, 1) == min_value
  assert wrapping_sub(min_value, 1) == max_value
  assert wrapping_mul(max_value, 2) == -2
  assert wrapping_neg(min_value) == min_value
}

// Tests of `std::int` that need this module.

test "from_i8 widens" {
  assert int::from_i8(-128) == -128
  assert int::from_i8(max_value) == 127
}

// Puzzle helpers. They sit at the end of the file, so no std location that
// a golden pins moves (D-1603).

/// Returns the greatest common divisor of `a` and `b`, which is never
/// negative, and `0` for `gcd(0, 0)` (D-1606). It panics only when the
/// result does not fit, as for `gcd(min_value, 0)`.
pub fn gcd(a: I8, b: I8) -> I8 {
  // Euclid's steps on values made non-positive, whose range holds the
  // negation of every `I8`, so only the last `-` can overflow.
  fn step(x: I8, y: I8) -> I8 {
    case y {
      0 => -x
      _ => step(y, x % y)
    }
  }
  step(non_positive(a), non_positive(b))
}

/// `n` with its sign made negative, which always fits.
priv fn non_positive(n: I8) -> I8 {
  case {
    n > 0 => -n
    _ => n
  }
}

/// Returns the least common multiple of `a` and `b`, which is never
/// negative, and `0` when either is `0` (D-1606). It panics when the result
/// does not fit.
pub fn lcm(a: I8, b: I8) -> I8 {
  case a, b {
    0, _ => 0
    _, 0 => 0
    _, _ => abs(a / gcd(a, b) * b)
  }
}

test "i8 gcd and lcm" {
  assert gcd(12, -18) == 6
  assert gcd(0, -5) == 5
  assert gcd(0, 0) == 0
  assert gcd(min_value, 6) == 2
  assert gcd(min_value, -1) == 1
  assert lcm(-4, 6) == 12
  assert lcm(0, 6) == 0
  assert lcm(max_value, 1) == max_value
}
