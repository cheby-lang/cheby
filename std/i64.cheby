//! The built-in `I64`, a signed 64-bit integer: constants, conversions,
//! parsing and text, comparison, and checked and wrapping arithmetic
//! (the integer families of `docs/stdlib/README.md`, D-350).
//!
//! `I64` itself is a builtin item whose home module is this one (D-447).

import std::int
import std::string

// Constants

/// The smallest `I64`.
pub const min_value: I64 = -9_223_372_036_854_775_808

/// The largest `I64`.
pub const max_value: I64 = 9_223_372_036_854_775_807

// Conversions

/// Returns `n` as an `I64`. Every `Int` fits.
@external(native, "cheby_i64_from_int")
@external(js, "./i64.mjs", "from_int")
pub fn from_int(n: Int) -> I64

/// Returns `n` as an `I64`. Every `I8` fits.
@external(native, "cheby_i64_from_i8")
@external(js, "./i64.mjs", "from_i8")
pub fn from_i8(n: I8) -> I64

/// Returns `n` as an `I64`. Every `I16` fits.
@external(native, "cheby_i64_from_i16")
@external(js, "./i64.mjs", "from_i16")
pub fn from_i16(n: I16) -> I64

/// Returns `n` as an `I64`. Every `I32` fits.
@external(native, "cheby_i64_from_i32")
@external(js, "./i64.mjs", "from_i32")
pub fn from_i32(n: I32) -> I64

/// Returns `n` as an `I64`. Every `U8` fits.
@external(native, "cheby_i64_from_u8")
@external(js, "./i64.mjs", "from_u8")
pub fn from_u8(n: U8) -> I64

/// Returns `n` as an `I64`. Every `U16` fits.
@external(native, "cheby_i64_from_u16")
@external(js, "./i64.mjs", "from_u16")
pub fn from_u16(n: U16) -> I64

/// Returns `n` as an `I64`. Every `U32` fits.
@external(native, "cheby_i64_from_u32")
@external(js, "./i64.mjs", "from_u32")
pub fn from_u32(n: U32) -> I64

/// Returns `n` as an `I64`, or `Err(Nil)` when it does not fit.
@external(native, "cheby_i64_from_u64")
@external(js, "./i64.mjs", "from_u64")
pub fn from_u64(n: U64) -> Result<I64, Nil>

/// Keeps the low 64 bits of `n`'s two's-complement value and reads them as an `I64` (D-1091).
pub fn wrapping_from_u64(n: U64) -> I64 {
  case n < 0x8000_0000_0000_0000 {
    True => {
      let assert Ok(value) = from_u64(n)
      value
    }
    False => {
      // `0xFFFF_FFFF_FFFF_FFFF - n` fits, and minus it minus 1 is `n` - 2^64.
      let assert Ok(complement) = from_u64(0xFFFF_FFFF_FFFF_FFFF - n)
      -complement - 1
    }
  }
}

test "wrapping_from keeps the low 64 bits of every source" {
  assert wrapping_from_u64(0) == 0
  assert wrapping_from_u64(1) == 1
  assert wrapping_from_u64(81_985_529_216_486_895) == 81_985_529_216_486_895
  assert wrapping_from_u64(9_223_372_036_854_775_807) == 9_223_372_036_854_775_807
  assert wrapping_from_u64(9_223_372_036_854_775_808) == -9_223_372_036_854_775_808
  assert wrapping_from_u64(18_446_744_073_709_551_615) == -1
}

// Parsing and text

/// Reads an `I64` written as an optional `-` and ASCII decimal digits (D-312).
@external(native, "cheby_i64_parse")
@external(js, "./i64.mjs", "parse")
pub fn parse(text: String) -> Result<I64, Nil>

/// Reads an `I64` written in `base`, from 2 to 36, as an optional `-` and digits.
@external(native, "cheby_i64_parse_base")
@external(js, "./i64.mjs", "parse_base")
pub fn parse_base(text: String, base: Int) -> Result<I64, Nil>

/// Returns `n` written in `base`, from 2 to 36, in lowercase digits (D-390, D-1090).
pub fn to_base(n: I64, base: Int) -> Result<String, Nil> {
  case base >= 2 && base <= 36 {
    False => Err(Nil)
    True => {
      // The digits of `-|n|`, which fits for every `n`, `min_value` too.
      let negative = case n > 0 {
        True => -n
        False => n
      }
      let digits = base_digits(negative, from_int(base), base, "")
      case n < 0 {
        True => Ok("-{digits}")
        False => Ok(digits)
      }
    }
  }
}

/// The digits of `-n` in `base`, for an `n` of 0 or below, in front of
/// `after`. `n % wide` has the sign of `n`, so its negation is the digit.
/// Each digit is below 36, so it fits `Int` on every target, where `n` may
/// not.
fn base_digits(n: I64, wide: I64, base: Int, after: String) -> String {
  let assert Ok(digit) = int::from_i64(-(n % wide))
  let assert Ok(text) = int::to_base(digit, base)
  case n / wide {
    0 => "{text}{after}"
    rest => base_digits(rest, wide, base, "{text}{after}")
  }
}

test "to_base writes every I64 in every base" {
  assert to_base(-9_223_372_036_854_775_808, 2) ==
    Ok("-1000000000000000000000000000000000000000000000000000000000000000")
  assert to_base(-9_223_372_036_854_775_808, 8) == Ok("-1000000000000000000000")
  assert to_base(-9_223_372_036_854_775_808, 10) == Ok("-9223372036854775808")
  assert to_base(-9_223_372_036_854_775_808, 16) == Ok("-8000000000000000")
  assert to_base(-9_223_372_036_854_775_808, 36) == Ok("-1y2p0ij32e8e8")
  assert to_base(-9_223_372_036_854_775_807, 2) ==
    Ok("-111111111111111111111111111111111111111111111111111111111111111")
  assert to_base(-9_223_372_036_854_775_807, 8) == Ok("-777777777777777777777")
  assert to_base(-9_223_372_036_854_775_807, 10) == Ok("-9223372036854775807")
  assert to_base(-9_223_372_036_854_775_807, 16) == Ok("-7fffffffffffffff")
  assert to_base(-9_223_372_036_854_775_807, 36) == Ok("-1y2p0ij32e8e7")
  assert to_base(-1, 2) == Ok("-1")
  assert to_base(-1, 8) == Ok("-1")
  assert to_base(-1, 10) == Ok("-1")
  assert to_base(-1, 16) == Ok("-1")
  assert to_base(-1, 36) == Ok("-1")
  assert to_base(0, 2) == Ok("0")
  assert to_base(0, 8) == Ok("0")
  assert to_base(0, 10) == Ok("0")
  assert to_base(0, 16) == Ok("0")
  assert to_base(0, 36) == Ok("0")
  assert to_base(1, 2) == Ok("1")
  assert to_base(1, 8) == Ok("1")
  assert to_base(1, 10) == Ok("1")
  assert to_base(1, 16) == Ok("1")
  assert to_base(1, 36) == Ok("1")
  assert to_base(81_985_529_216_486_895, 2) ==
    Ok("100100011010001010110011110001001101010111100110111101111")
  assert to_base(81_985_529_216_486_895, 8) == Ok("4432126361152746757")
  assert to_base(81_985_529_216_486_895, 10) == Ok("81985529216486895")
  assert to_base(81_985_529_216_486_895, 16) == Ok("123456789abcdef")
  assert to_base(81_985_529_216_486_895, 36) == Ok("mf9g063v08f")
  assert to_base(9_223_372_036_854_775_807, 2) ==
    Ok("111111111111111111111111111111111111111111111111111111111111111")
  assert to_base(9_223_372_036_854_775_807, 8) == Ok("777777777777777777777")
  assert to_base(9_223_372_036_854_775_807, 10) == Ok("9223372036854775807")
  assert to_base(9_223_372_036_854_775_807, 16) == Ok("7fffffffffffffff")
  assert to_base(9_223_372_036_854_775_807, 36) == Ok("1y2p0ij32e8e7")
  assert to_base(max_value, 0) == Err(Nil)
  assert to_base(max_value, -16) == Err(Nil)
  assert to_base(min_value, 37) == Err(Nil)
  fn round_trips(n: I64, base: Int) -> Bool {
    case base > 36 {
      True => True
      False => {
        let assert Ok(text) = to_base(n, base)
        parse_base(text, base) == Ok(n) && round_trips(n, base + 1)
      }
    }
  }
  assert round_trips(-9_223_372_036_854_775_808, 2)
  assert round_trips(-9_223_372_036_854_775_807, 2)
  assert round_trips(-1, 2)
  assert round_trips(0, 2)
  assert round_trips(1, 2)
  assert round_trips(9_223_372_036_854_775_807, 2)
}

/// Returns `n` in decimal. It makes `I64` satisfy `Show`.
@external(native, "cheby_i64_show")
@external(js, "./i64.mjs", "show")
pub fn show(n: I64) -> String

// Comparison

/// Orders two `I64` values. It makes `I64` satisfy `Compare`.
pub fn compare(a: I64, b: I64) -> Order {
  case {
    a < b => Less
    a > b => Greater
    _ => Equal
  }
}

/// Returns the smaller of `a` and `b`, and `a` when they are `Equal`.
pub fn min(a: I64, b: I64) -> I64 {
  case {
    b < a => b
    _ => a
  }
}

/// Returns the larger of `a` and `b`, and `a` when they are `Equal`.
pub fn max(a: I64, b: I64) -> I64 {
  case {
    b > a => b
    _ => a
  }
}

// Arithmetic

/// Returns `a + b`, and panics when the result does not fit. It makes `I64` satisfy `Add`.
pub fn add(a: I64, b: I64) -> I64 {
  a + b
}

/// Returns `a - b`, and panics when the result does not fit. It makes `I64` satisfy `Sub`.
pub fn sub(a: I64, b: I64) -> I64 {
  a - b
}

/// Returns `a * b`, and panics when the result does not fit. It makes `I64` satisfy `Mul`.
pub fn mul(a: I64, b: I64) -> I64 {
  a * b
}

/// Returns `a / b` toward zero, panicking like `/`. It makes `I64` satisfy `Div`.
pub fn div(a: I64, b: I64) -> I64 {
  a / b
}

/// Returns `a % b`, with the sign of `a`, and panics on a zero divisor.
pub fn rem(a: I64, b: I64) -> I64 {
  a % b
}

/// Returns `-n`, and panics when it does not fit. It makes `I64` satisfy `Neg`.
pub fn neg(n: I64) -> I64 {
  -n
}

/// Returns `n` without its sign, and panics for `min_value`, like `neg`.
pub fn abs(n: I64) -> I64 {
  case {
    n < 0 => -n
    _ => n
  }
}

// Checked arithmetic

/// Returns `Ok(a + b)`, or `Err(Nil)` when the sum does not fit (D-309).
@external(native, "cheby_i64_checked_add")
@external(js, "./i64.mjs", "checked_add")
pub fn checked_add(a: I64, b: I64) -> Result<I64, Nil>

/// Returns `Ok(a - b)`, or `Err(Nil)` when the difference does not fit (D-309).
@external(native, "cheby_i64_checked_sub")
@external(js, "./i64.mjs", "checked_sub")
pub fn checked_sub(a: I64, b: I64) -> Result<I64, Nil>

/// Returns `Ok(a * b)`, or `Err(Nil)` when the product does not fit (D-309).
@external(native, "cheby_i64_checked_mul")
@external(js, "./i64.mjs", "checked_mul")
pub fn checked_mul(a: I64, b: I64) -> Result<I64, Nil>

/// Returns `Ok(a / b)`, or `Err(Nil)` for a zero divisor and for `min_value / -1` (D-356).
pub fn checked_div(a: I64, b: I64) -> Result<I64, Nil> {
  // Dividing by -1 overflows exactly when negating does.
  case b {
    0 => Err(Nil)
    -1 => checked_neg(a)
    _ => Ok(a / b)
  }
}

/// Returns `Ok(a % b)`, or `Err(Nil)` for a zero divisor (D-356).
pub fn checked_rem(a: I64, b: I64) -> Result<I64, Nil> {
  case b {
    0 => Err(Nil)
    _ => Ok(a % b)
  }
}

/// Returns `Ok(-n)`, or `Err(Nil)` for `min_value` (D-309).
pub fn checked_neg(n: I64) -> Result<I64, Nil> {
  case {
    n == min_value => Err(Nil)
    _ => Ok(-n)
  }
}

// Wrapping arithmetic

/// Returns `a + b` modulo 2^64 (D-025).
@external(native, "cheby_i64_wrapping_add")
@external(js, "./i64.mjs", "wrapping_add")
pub fn wrapping_add(a: I64, b: I64) -> I64

/// Returns `a - b` modulo 2^64 (D-025).
@external(native, "cheby_i64_wrapping_sub")
@external(js, "./i64.mjs", "wrapping_sub")
pub fn wrapping_sub(a: I64, b: I64) -> I64

/// Returns `a * b` modulo 2^64 (D-025).
@external(native, "cheby_i64_wrapping_mul")
@external(js, "./i64.mjs", "wrapping_mul")
pub fn wrapping_mul(a: I64, b: I64) -> I64

/// Returns `-n` modulo 2^64 (D-025).
@external(native, "cheby_i64_wrapping_neg")
@external(js, "./i64.mjs", "wrapping_neg")
pub fn wrapping_neg(n: I64) -> I64

// Examples

test "the i64 range" {
  assert min_value == -9_223_372_036_854_775_808
  assert max_value == 9_223_372_036_854_775_807
}

test "i64 parses and shows decimal digits" {
  let small: I64 = -5
  assert parse("-9223372036854775808") == Ok(min_value)
  assert parse("9223372036854775808") == Err(Nil)
  assert parse_base("7fffffffffffffff", 16) == Ok(max_value)
  assert show(max_value) == "9223372036854775807"
  assert "{small}" == "-5"
  assert to_base(max_value, 16) == Ok("7fffffffffffffff")
  assert to_base(min_value, 2) ==
    Ok("-1000000000000000000000000000000000000000000000000000000000000000")
  assert to_base(35, 36) == Ok("z")
  assert to_base(max_value, 37) == Err(Nil)
  assert to_base(max_value, 1) == Err(Nil)
}

test "comparing i64 values" {
  assert compare(-1, 1) == Less
  assert compare(3, 3) == Equal
  assert min(-100, 7) == -100
  assert max(-100, 7) == 7
}

test "i64 operators as functions" {
  assert add(100, 27) == 127
  assert sub(-100, 28) == -128
  assert mul(-4, 5) == -20
  assert div(-7, 2) == -3
  assert rem(-7, 2) == -1
  assert neg(127) == -127
  assert abs(-127) == 127
}

test "i64 checked arithmetic reports overflow" {
  assert checked_add(100, 27) == Ok(127)
  assert checked_add(max_value, 1) == Err(Nil)
  assert checked_sub(min_value, 1) == Err(Nil)
  assert checked_mul(max_value, 2) == Err(Nil)
  assert checked_div(min_value, -1) == Err(Nil)
  assert checked_rem(7, 0) == Err(Nil)
  assert checked_neg(min_value) == Err(Nil)
}

test "i64 wrapping arithmetic wraps around" {
  assert wrapping_add(max_value, 1) == min_value
  assert wrapping_sub(min_value, 1) == max_value
  assert wrapping_mul(max_value, 2) == -2
  assert wrapping_neg(min_value) == min_value
}

// Tests of `std::int` that need this module.

@target(native)
test "from_i64 keeps every I64 on native" {
  assert int::from_i64(max_value) == Ok(int::max_value)
}

// Puzzle helpers. They sit at the end of the file, so no std location that
// a golden pins moves (D-1603).

/// Returns the greatest common divisor of `a` and `b`, which is never
/// negative, and `0` for `gcd(0, 0)` (D-1606). It panics only when the
/// result does not fit, as for `gcd(min_value, 0)`.
pub fn gcd(a: I64, b: I64) -> I64 {
  // Euclid's steps on values made non-positive, whose range holds the
  // negation of every `I64`, so only the last `-` can overflow.
  fn step(x: I64, y: I64) -> I64 {
    case y {
      0 => -x
      _ => step(y, x % y)
    }
  }
  step(non_positive(a), non_positive(b))
}

/// `n` with its sign made negative, which always fits.
priv fn non_positive(n: I64) -> I64 {
  case {
    n > 0 => -n
    _ => n
  }
}

/// Returns the least common multiple of `a` and `b`, which is never
/// negative, and `0` when either is `0` (D-1606). It panics when the result
/// does not fit.
pub fn lcm(a: I64, b: I64) -> I64 {
  case a, b {
    0, _ => 0
    _, 0 => 0
    _, _ => abs(a / gcd(a, b) * b)
  }
}

test "i64 gcd and lcm" {
  assert gcd(12, -18) == 6
  assert gcd(0, -5) == 5
  assert gcd(0, 0) == 0
  assert gcd(min_value, 6) == 2
  assert gcd(min_value, -1) == 1
  assert lcm(-4, 6) == 12
  assert lcm(0, 6) == 0
  assert lcm(max_value, 1) == max_value
}
