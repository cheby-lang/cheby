//! The raw JSON tree that `std::json` and `std::json::decode` share, and
//! the parser of JSON text (D-361, ADR-0053).
//!
//! `std::json` imports `std::json::decode`, so the decoders cannot name
//! `json::Value` (D-145). Both modules import this one instead: the parser
//! reads text into a `Tree` for the decoders, the decoders run over a
//! `Tree`, and `std::json` converts a `json::Value` to a `Tree` with
//! `rebuild`. The parser is generic over the values it builds, so
//! `json::parse_value` reads text straight into a `json::Value` through a
//! `Builder`.
//!
//! This is the internal module of D-361 (D-483). Its items are
//! package-visible, never `pub`, so no other package can use them.
//!
//! The parser scans the UTF-8 bytes of the text by offset. It tracks no
//! line or column: when the text is not JSON, it counts them from the start
//! up to the offset of the error. It reads the text of strings and numbers
//! with the package-visible `string::from_byte_range` (D-905). The bytes
//! are the UTF-8 of a `String` and every cut falls next to an ASCII byte,
//! so no range holds invalid UTF-8.
//!
//! Nothing here grows the stack with the nesting depth of a document: the
//! parser keeps the arrays and objects it is inside of in a chain of cells
//! on the heap, `rebuild` keeps its work in a list on the heap, and every
//! other loop is a tail call (D-094, D-326).

import std::bytes
import std::float
import std::int
import std::list
import std::string

/// A JSON value as the parser reads it, with the shapes of `json::Value` (D-321).
type Tree {
  Null,
  Bool(Bool),
  Int(Int),
  Float(Float),
  String(String),
  Array(List<Tree>),
  Object(List<(String, Tree)>),
}

/// Returns the kind of `value` as `decode::Error` names it in `found` (D-323).
fn kind(value: Tree) -> String {
  case value {
    Null => "Null"
    Bool(_) => "Bool"
    Int(_) => "Int"
    Float(_) => "Float"
    String(_) => "String"
    Array(_) => "Array"
    Object(_) => "Object"
  }
}

// Converting

/// What `rebuild` finds in one node of a document: a leaf already converted,
/// or the children of an array or an object, still to be converted.
type Children<A, B> {
  Leaf(B),
  Items(List<A>),
  Members(List<(String, A)>),
}

/// A step of `rebuild`: a node to visit, or an array or object to build
/// from the nodes converted last.
priv type Task<A> {
  Visit(A),
  BuildArray(Int),
  BuildObject(List<String>),
}

/// Converts a document from one tree type to another without growing the
/// stack with its depth. `open` takes a node apart, and `array` and
/// `object` build a converted array or object from converted children.
fn rebuild<A, B>(
  root: A,
  open: fn(A) -> Children<A, B>,
  array: fn(List<B>) -> B,
  object: fn(List<(String, B)>) -> B,
) -> B {
  // `tasks` is a stack whose top is its last element. `done` holds the
  // converted nodes whose array or object is not built yet, in order.
  fn step(tasks: List<Task<A>>, done: List<B>) -> B {
    case tasks {
      [] => {
        let assert [converted] = done
        converted
      }
      [..rest, Visit(node)] => case open(node) {
        Leaf(converted) => step(rest, list::push(done, converted))
        Items(items) => {
          let visits = list::reverse(list::map(items, Visit))
          let build = BuildArray(list::length(items))
          step(list::append(list::push(rest, build), visits), done)
        }
        Members(members) => {
          let keys = list::map(members, fn((key, _)) { key })
          let visits = list::reverse(list::map(members, fn((_, child)) { Visit(child) }))
          step(list::append(list::push(rest, BuildObject(keys)), visits), done)
        }
      }
      [..rest, BuildArray(size)] => {
        let (kept, items) = list::split_at(done, list::length(done) - size)
        step(rest, list::push(kept, array(items)))
      }
      [..rest, BuildObject(keys)] => {
        let (kept, values) = list::split_at(done, list::length(done) - list::length(keys))
        let built = object(list::zip(keys, values))
        step(rest, list::push(kept, built))
      }
    }
  }
  step([Visit(root)], [])
}

// Parsing

/// How the parser builds the values of a document of type `T`: one
/// function or value for each shape of `json::Value` (D-321).
type Builder<T> {
  null: T,
  bool: fn(Bool) -> T,
  int: fn(Int) -> T,
  float: fn(Float) -> T,
  string: fn(String) -> T,
  array: fn(List<T>) -> T,
  object: fn(List<(String, T)>) -> T,
}

/// The arrays and objects whose elements are still being read, innermost
/// first: the elements of each so far, and for an object the key of the
/// member being read. `Top` stands outside the document's value. It is a
/// chain of cells rather than a list, so opening and closing an array or
/// object allocates or frees one cell and calls no list kernel.
priv type Stack<T> {
  Top,
  InArray(List<T>, Stack<T>),
  InObject(List<(String, T)>, String, Stack<T>),
}

/// What reading a document gives: the value, or the byte offset of the
/// syntax error.
priv type Parsed<T> = Result<T, Int>

/// What reading a string gives: the string and the offset after its closing
/// `"`, or the offset of the syntax error.
priv type ReadString = Result<(String, Int), Int>

/// Parses `text` into a `Tree`, as `parse_with` does.
fn parse(text: String) -> Result<Tree, (Int, Int)> {
  let builder = Builder {
    null: Null,
    bool: Bool,
    int: Int,
    float: Float,
    string: String,
    array: Array,
    object: Object,
  }
  parse_with(text, builder)
}

/// Parses `text` as one JSON value (RFC 8259) with optional whitespace
/// around it, building each value with `builder`. A syntax error gives the
/// line and the column, both counting from 1, of the first code point at
/// which `text` stops being the start of a JSON text, or of the position
/// just after its end when it ends too early (D-324).
fn parse_with<T>(text: String, builder: Builder<T>) -> Result<T, (Int, Int)> {
  let data = bytes::from_string(text)
  case read_value(builder, data, 0, Top) {
    Ok(value) => Ok(value)
    Err(offset) => Err(position(data, offset))
  }
}

/// Returns the line and the column of the code point at byte `offset` of
/// `data`, or of the position just after the end. A line ends at `\n`, and
/// the column counts code points (D-302, D-324): the bytes that do not
/// continue a UTF-8 sequence.
priv fn position(data: bytes::Bytes, offset: Int) -> (Int, Int) {
  fn step(index: Int, line: Int, column: Int) -> (Int, Int) {
    case index >= offset {
      True => (line, column)
      False => case bytes::get(data, index) {
        Some(0x0A) => step(index + 1, line + 1, 1)
        Some(byte) when byte >= 0x80 && byte < 0xC0 => step(index + 1, line, column)
        _ => step(index + 1, line, column + 1)
      }
    }
  }
  step(0, 1, 1)
}

// Every function that expects the next token (`read_value`, `open_array`,
// `open_object`, `read_key`, `read_colon`, `read_end`, `after_item` and
// `after_member`) starts at a byte that may be whitespace, and moves past
// spaces, tabs, line feeds and carriage returns, the only whitespace of
// RFC 8259, by calling itself at the next byte.
//
// `read_colon` and `close_value` take the innermost cell of the stack apart
// and build its new version in the same `case` arm or block, so Perceus
// writes the new cell over the old one in place (D-838). Keep the rebuild
// there. Reuse pairs only when the rebuild is in a block that only the
// block taking the cell apart enters (D-839). A `let x = case ..` between
// the two joins the arms, and then the old cell is freed and a new one
// allocated: the results stay the same, and nothing warns. The test
// `json_containers_reuse_their_cells` in `crates/cheby_cli/tests/run.rs`
// counts the reuse hits of a parse and a write, and fails when a step loses
// its reuse.

/// Reads one value at `i` inside the arrays and objects of `stack`.
priv fn read_value<T>(
  builder: Builder<T>,
  data: bytes::Bytes,
  i: Int,
  stack: Stack<T>,
) -> Parsed<T> {
  case bytes::get(data, i) {
    Some(0x20) | Some(0x0A) | Some(0x09) | Some(0x0D) => {
      read_value(builder, data, i + 1, stack)
    }
    // `{`
    Some(0x7B) => open_object(builder, data, i + 1, stack)
    // `[`
    Some(0x5B) => open_array(builder, data, i + 1, stack)
    // `"`
    Some(0x22) => {
      let end = bytes::json_plain_end(data, i + 1)
      case bytes::get(data, end) {
        // A string with no escape is a slice of the text.
        Some(0x22) => {
          let text = string::from_byte_range(data, i + 1, end)
          close_value(builder, data, builder.string(text), end + 1, stack)
        }
        _ => case read_string(data, i + 1, end, []) {
          Ok((text, after)) => close_value(builder, data, builder.string(text), after, stack)
          Err(offset) => Err(offset)
        }
      }
    }
    // `t`, `f` and `n` start `true`, `false` and `null`. The rest of each
    // word is packed into an `Int`, its first byte lowest.
    Some(0x74) => {
      let end = word_end(data, i + 1, 0x657572, 3)
      case end == i + 4 {
        True => close_value(builder, data, builder.bool(True), end, stack)
        False => Err(end)
      }
    }
    Some(0x66) => {
      let end = word_end(data, i + 1, 0x65736C61, 4)
      case end == i + 5 {
        True => close_value(builder, data, builder.bool(False), end, stack)
        False => Err(end)
      }
    }
    Some(0x6E) => {
      let end = word_end(data, i + 1, 0x6C6C75, 3)
      case end == i + 4 {
        True => close_value(builder, data, builder.null, end, stack)
        False => Err(end)
      }
    }
    // `-` or a digit
    Some(0x2D) => read_integer_part(builder, data, i, i + 1, True, stack)
    Some(byte) when byte >= 0x30 && byte <= 0x39 => {
      read_integer_part(builder, data, i, i, False, stack)
    }
    _ => Err(i)
  }
}

/// Returns the offset of the first byte from `i` that is not the next byte
/// of `rest`, the last `size` bytes of `true`, `false` or `null` packed
/// into an `Int` with the first one lowest, or `i + size` when they all
/// match.
priv fn word_end(data: bytes::Bytes, i: Int, rest: Int, size: Int) -> Int {
  case size {
    0 => i
    _ => case bytes::get(data, i) {
      Some(byte) when int::from_u8(byte) == rest & 0xFF => {
        word_end(data, i + 1, rest >> 8, size - 1)
      }
      _ => i
    }
  }
}

/// Starts an array after its `[`.
priv fn open_array<T>(
  builder: Builder<T>,
  data: bytes::Bytes,
  i: Int,
  stack: Stack<T>,
) -> Parsed<T> {
  case bytes::get(data, i) {
    Some(0x20) | Some(0x0A) | Some(0x09) | Some(0x0D) => {
      open_array(builder, data, i + 1, stack)
    }
    // `]`
    Some(0x5D) => close_value(builder, data, builder.array([]), i + 1, stack)
    _ => read_value(builder, data, i, InArray([], stack))
  }
}

/// Starts an object after its `{`. Its cell holds an empty key until
/// `read_colon` writes the first member's key into it.
priv fn open_object<T>(
  builder: Builder<T>,
  data: bytes::Bytes,
  i: Int,
  stack: Stack<T>,
) -> Parsed<T> {
  case bytes::get(data, i) {
    Some(0x20) | Some(0x0A) | Some(0x09) | Some(0x0D) => {
      open_object(builder, data, i + 1, stack)
    }
    // `}`
    Some(0x7D) => close_value(builder, data, builder.object([]), i + 1, stack)
    _ => read_key(builder, data, i, InObject([], "", stack))
  }
}

/// Reads a member's key, then its `:` and its value, in the object that is
/// the innermost cell of `stack`.
priv fn read_key<T>(builder: Builder<T>, data: bytes::Bytes, i: Int, stack: Stack<T>) -> Parsed<T> {
  case bytes::get(data, i) {
    Some(0x20) | Some(0x0A) | Some(0x09) | Some(0x0D) => read_key(builder, data, i + 1, stack)
    // `"`
    Some(0x22) => {
      let end = bytes::json_plain_end(data, i + 1)
      case bytes::get(data, end) {
        Some(0x22) => {
          let key = string::from_byte_range(data, i + 1, end)
          read_colon(builder, data, end + 1, key, stack)
        }
        _ => case read_string(data, i + 1, end, []) {
          Ok((key, after)) => read_colon(builder, data, after, key, stack)
          Err(offset) => Err(offset)
        }
      }
    }
    _ => Err(i)
  }
}

/// Reads the `:` after the member's key `key`, then its value. It writes
/// `key` into the object's cell, which it takes apart and builds again, so
/// Perceus updates the cell in place (D-838).
priv fn read_colon<T>(
  builder: Builder<T>,
  data: bytes::Bytes,
  i: Int,
  key: String,
  stack: Stack<T>,
) -> Parsed<T> {
  case bytes::get(data, i) {
    Some(0x20) | Some(0x0A) | Some(0x09) | Some(0x0D) => {
      read_colon(builder, data, i + 1, key, stack)
    }
    // `:`
    Some(0x3A) => {
      let assert InObject(members, _, below) = stack
      read_value(builder, data, i + 1, InObject(members, key, below))
    }
    _ => Err(i)
  }
}

/// Adds the complete `value` to the innermost array or object of `stack`,
/// and reads what follows it at `i`. It takes the innermost cell apart and
/// builds it again with the new element, so Perceus updates the cell in
/// place (D-838).
priv fn close_value<T>(
  builder: Builder<T>,
  data: bytes::Bytes,
  value: T,
  i: Int,
  stack: Stack<T>,
) -> Parsed<T> {
  case stack {
    Top => read_end(data, i, value)
    InArray(items, below) => after_item(builder, data, i, InArray([..items, value], below))
    InObject(members, key, below) => {
      after_member(builder, data, i, InObject([..members, (key, value)], key, below))
    }
  }
}

/// Reads the whitespace after the document's value up to the end.
priv fn read_end<T>(data: bytes::Bytes, i: Int, value: T) -> Parsed<T> {
  case bytes::get(data, i) {
    Some(0x20) | Some(0x0A) | Some(0x09) | Some(0x0D) => read_end(data, i + 1, value)
    None => Ok(value)
    _ => Err(i)
  }
}

/// Reads the `,` or `]` after an element of the array that is the innermost
/// cell of `stack`.
priv fn after_item<T>(
  builder: Builder<T>,
  data: bytes::Bytes,
  i: Int,
  stack: Stack<T>,
) -> Parsed<T> {
  case bytes::get(data, i) {
    Some(0x20) | Some(0x0A) | Some(0x09) | Some(0x0D) => after_item(builder, data, i + 1, stack)
    // `,`
    Some(0x2C) => read_value(builder, data, i + 1, stack)
    // `]`
    Some(0x5D) => {
      let assert InArray(items, below) = stack
      close_value(builder, data, builder.array(items), i + 1, below)
    }
    _ => Err(i)
  }
}

/// Reads the `,` or `}` after a member of the object that is the innermost
/// cell of `stack`.
priv fn after_member<T>(
  builder: Builder<T>,
  data: bytes::Bytes,
  i: Int,
  stack: Stack<T>,
) -> Parsed<T> {
  case bytes::get(data, i) {
    Some(0x20) | Some(0x0A) | Some(0x09) | Some(0x0D) => after_member(builder, data, i + 1, stack)
    // `,`
    Some(0x2C) => read_key(builder, data, i + 1, stack)
    // `}`
    Some(0x7D) => {
      let assert InObject(members, _, below) = stack
      close_value(builder, data, builder.object(members), i + 1, below)
    }
    _ => Err(i)
  }
}

// Strings

/// Reads the rest of a string with an escape, from `i`. The text from
/// `from` to `i` has no escape yet, and the text before it is in `parts`.
priv fn read_string(data: bytes::Bytes, from: Int, i: Int, parts: List<String>) -> ReadString {
  case bytes::get(data, i) {
    // `"`
    Some(0x22) => {
      let all = list::push(parts, string::from_byte_range(data, from, i))
      Ok((string::join(all, ""), i + 1))
    }
    // `\`
    Some(0x5C) => {
      let all = list::push(parts, string::from_byte_range(data, from, i))
      read_escape(data, i + 1, all)
    }
    // Control characters must be escaped.
    Some(byte) when byte >= 0x20 => {
      read_string(data, from, bytes::json_plain_end(data, i + 1), parts)
    }
    _ => Err(i)
  }
}

/// Reads an escape after its `\`.
priv fn read_escape(data: bytes::Bytes, i: Int, parts: List<String>) -> ReadString {
  case bytes::get(data, i) {
    // `u`
    Some(0x75) => read_unicode(data, i + 1, parts)
    Some(letter) => case escaped(letter) {
      Some(text) => read_string(data, i + 1, i + 1, list::push(parts, text))
      None => Err(i)
    }
    None => Err(i)
  }
}

/// Returns the text that a one-letter escape stands for.
priv fn escaped(letter: U8) -> Option<String> {
  case letter {
    // `"`, `\` and `/` stand for themselves.
    0x22 => Some("\"")
    0x5C => Some("\\")
    0x2F => Some("/")
    // `b`, `f`, `n`, `r` and `t`
    0x62 => Some("\u{8}")
    0x66 => Some("\u{C}")
    0x6E => Some("\n")
    0x72 => Some("\r")
    0x74 => Some("\t")
    _ => None
  }
}

/// Returns the text of the scalar value `point`.
priv fn point_text(point: Int) -> String {
  // Surrogate escapes are accepted only in pairs, so `point` is a scalar
  // value (D-326).
  let assert Ok(text) = string::from_code_point_values([point])
  text
}

/// Reads the four hex digits of a `\u` escape at `i`. A high surrogate must
/// be followed by the escape of a low surrogate, and the pair is one code
/// point. A low surrogate on its own is an error (D-326).
priv fn read_unicode(data: bytes::Bytes, i: Int, parts: List<String>) -> ReadString {
  case read_hex(data, i, 0, 0, False) {
    Ok(unit) => case unit >= 0xD800 && unit <= 0xDBFF {
      True => read_low_surrogate(data, i + 4, unit, parts)
      False => read_string(data, i + 4, i + 4, list::push(parts, point_text(unit)))
    }
    Err(offset) => Err(offset)
  }
}

/// Reads the `\u` escape of the low surrogate that must follow the high
/// surrogate `high`, at `i`.
priv fn read_low_surrogate(
  data: bytes::Bytes,
  i: Int,
  high: Int,
  parts: List<String>,
) -> ReadString {
  case bytes::get(data, i), bytes::get(data, i + 1) {
    // `\u`
    Some(0x5C), Some(0x75) => case read_hex(data, i + 2, 0, 0, True) {
      Ok(low) => {
        let point = 0x10000 + (high - 0xD800) * 0x400 + (low - 0xDC00)
        read_string(data, i + 6, i + 6, list::push(parts, point_text(point)))
      }
      Err(offset) => Err(offset)
    }
    // `\` followed by something other than `u`
    Some(0x5C), _ => Err(i + 1)
    _, _ => Err(i)
  }
}

/// Reads the hex digits of a `\u` escape that starts at `start`, from the
/// one at `index`, with the value of the earlier ones in `value`. Each
/// digit is checked as soon as it is read, so an error points at the first
/// digit that no valid escape could have: one that is not hex, the second
/// digit of a low surrogate that is not part of a pair, or, when `low` is
/// `True`, a first or second digit that does not start a low surrogate.
priv fn read_hex(
  data: bytes::Bytes,
  start: Int,
  index: Int,
  value: Int,
  low: Bool,
) -> Result<Int, Int> {
  case index {
    4 => Ok(value)
    _ => case bytes::get(data, start + index) {
      Some(byte) => case hex_digit(byte) {
        Some(digit) when hex_fits(index, value, digit, low) => {
          read_hex(data, start, index + 1, value * 16 + digit, low)
        }
        _ => Err(start + index)
      }
      None => Err(start + index)
    }
  }
}

/// Tells whether `digit`, at `index` after the digits whose value is
/// `before`, can still be part of a valid escape. Surrogates are
/// `D800` to `DFFF`, and low ones `DC00` to `DFFF`.
priv fn hex_fits(index: Int, before: Int, digit: Int, low: Bool) -> Bool {
  case low, index {
    True, 0 => digit == 0xD
    True, 1 => digit >= 0xC
    False, 1 => before != 0xD || digit < 0xC
    _, _ => True
  }
}

/// Returns the value of an ASCII hex digit, in either case.
priv fn hex_digit(byte: U8) -> Option<Int> {
  let point = int::from_u8(byte)
  case {
    point >= 0x30 && point <= 0x39 => Some(point - 0x30)
    point >= 0x41 && point <= 0x46 => Some(point - 0x37)
    point >= 0x61 && point <= 0x66 => Some(point - 0x57)
    _ => None
  }
}

// Numbers
//
// Digits are tested inline rather than through a helper, which saves about
// 1% of a parse's instructions (D-906). Keep them inline.

/// Reads a number that starts at `start` from its integer part at `first`,
/// after the `-` when `negative` is `True`. A number is an optional `-`, an
/// integer part with no leading zeros, an optional fraction and an optional
/// exponent.
priv fn read_integer_part<T>(
  builder: Builder<T>,
  data: bytes::Bytes,
  start: Int,
  first: Int,
  negative: Bool,
  stack: Stack<T>,
) -> Parsed<T> {
  case bytes::get(data, first) {
    // `0` is the whole integer part.
    Some(0x30) => read_fraction(builder, data, start, first + 1, 0, negative, stack)
    Some(byte) when byte >= 0x30 && byte <= 0x39 => {
      read_integer(builder, data, start, first, 0, 0, negative, stack)
    }
    _ => Err(first)
  }
}

/// Reads the digits of the integer part from `i`, `count` of them read
/// already. While there are at most 15, `value` is their value, which
/// stays below 2⁵³; after that it is -1, and the number is read from its
/// text, so no `Int` beyond 2⁵³ is built on JS (D-037).
priv fn read_integer<T>(
  builder: Builder<T>,
  data: bytes::Bytes,
  start: Int,
  i: Int,
  value: Int,
  count: Int,
  negative: Bool,
  stack: Stack<T>,
) -> Parsed<T> {
  case bytes::get(data, i) {
    Some(byte) when byte >= 0x30 && byte <= 0x39 => {
      let next = case count < 15 {
        True => value * 10 + int::from_u8(byte) - 0x30
        False => -1
      }
      read_integer(builder, data, start, i + 1, next, count + 1, negative, stack)
    }
    _ => read_fraction(builder, data, start, i, value, negative, stack)
  }
}

/// Reads an optional fraction, `.` and one or more digits, at `i`. `value`
/// is the value of the integer part, or -1 when it has more than 15 digits.
priv fn read_fraction<T>(
  builder: Builder<T>,
  data: bytes::Bytes,
  start: Int,
  i: Int,
  value: Int,
  negative: Bool,
  stack: Stack<T>,
) -> Parsed<T> {
  case bytes::get(data, i) {
    // `.`
    Some(0x2E) => case bytes::get(data, i + 1) {
      Some(byte) when byte >= 0x30 && byte <= 0x39 => {
        read_exponent(builder, data, start, skip_digits(data, i + 2), False, stack)
      }
      _ => Err(i + 1)
    }
    _ => case value >= 0 {
      True => read_small_integer(builder, data, start, i, value, negative, stack)
      False => read_exponent(builder, data, start, i, True, stack)
    }
  }
}

/// Closes an integer of at most 15 digits whose value is `value`, unless
/// an exponent follows at `i`.
priv fn read_small_integer<T>(
  builder: Builder<T>,
  data: bytes::Bytes,
  start: Int,
  i: Int,
  value: Int,
  negative: Bool,
  stack: Stack<T>,
) -> Parsed<T> {
  case bytes::get(data, i) {
    // `e` or `E`
    Some(0x65) | Some(0x45) => read_exponent(builder, data, start, i, True, stack)
    _ => {
      let n = case negative {
        True => -value
        False => value
      }
      close_value(builder, data, builder.int(n), i, stack)
    }
  }
}

/// Reads an optional exponent at `i`: `e` or `E`, an optional sign and one
/// or more digits. `integral` tells whether the number had no fraction.
priv fn read_exponent<T>(
  builder: Builder<T>,
  data: bytes::Bytes,
  start: Int,
  i: Int,
  integral: Bool,
  stack: Stack<T>,
) -> Parsed<T> {
  case bytes::get(data, i) {
    // `e` or `E`
    Some(0x65) | Some(0x45) => {
      let digits = case bytes::get(data, i + 1) {
        // `+` or `-`
        Some(0x2B) | Some(0x2D) => i + 2
        _ => i + 1
      }
      case bytes::get(data, digits) {
        Some(byte) when byte >= 0x30 && byte <= 0x39 => {
          let end = skip_digits(data, digits + 1)
          close_number(builder, data, start, end, False, stack)
        }
        _ => Err(digits)
      }
    }
    _ => close_number(builder, data, start, i, integral, stack)
  }
}

/// Returns the offset of the first byte from `i` that is not a digit.
priv fn skip_digits(data: bytes::Bytes, i: Int) -> Int {
  case bytes::get(data, i) {
    Some(byte) when byte >= 0x30 && byte <= 0x39 => skip_digits(data, i + 1)
    _ => i
  }
}

/// Closes the number written by the bytes from `start` to `end`.
priv fn close_number<T>(
  builder: Builder<T>,
  data: bytes::Bytes,
  start: Int,
  end: Int,
  integral: Bool,
  stack: Stack<T>,
) -> Parsed<T> {
  let value = number(builder, string::from_byte_range(data, start, end), integral)
  close_value(builder, data, value, end, stack)
}

/// Returns the value of a number's text. One without a fraction or an
/// exponent is an `Int` when it lies within ±(2⁵³−1), on every target, and
/// every other number is the nearest `Float`, an infinity or a zero with
/// its sign beyond `Float`'s range (D-217, D-222, D-394).
priv fn number<T>(builder: Builder<T>, text: String, integral: Bool) -> T {
  case integral && is_safe_integer(text) {
    True => {
      let assert Ok(n) = int::parse(text)
      builder.int(n)
    }
    False => {
      let assert Ok(x) = float::parse(text)
      builder.float(x)
    }
  }
}

/// Tells whether the integer `text`, which has no leading zeros, lies
/// within ±(2⁵³−1). It compares digits, so it never builds an `Int` that
/// would panic on JS (D-037).
priv fn is_safe_integer(text: String) -> Bool {
  let magnitude = string::remove_prefix(text, "-")
  let size = string::length(magnitude)
  case {
    size < 16 => True
    size == 16 => string::compare(magnitude, "9007199254740991") != Greater
    _ => False
  }
}
