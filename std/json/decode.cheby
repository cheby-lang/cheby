//! Decoders, which turn a JSON value into typed data (D-320). A decoder is
//! built from the primitive decoders and combined with `use` through
//! `field`, `optional_field` and `then`. `json::parse` and
//! `json::decode_value` run them.
//!
//! This module cannot import `std::json`, which imports it (D-145, D-361),
//! so decoders run over the raw tree of `std::json::tree` rather than over
//! `json::Value` (ADR-0053).
//!
//! Decoding reports every value that did not fit (D-322). A decoder that
//! fails records its error and gives a placeholder of its type, so decoding
//! goes on and later values are checked too (D-401). Errors are kept in
//! the order the values are visited, and an error equal to one recorded
//! already is dropped (D-404).
//!
//! A decoder is built eagerly, so a decoder that refers to itself goes
//! through `lazy`, which builds the inner decoder only when it decodes a
//! value and gives its own placeholder where no value is decoded (D-1086).
//!
//! A decoder records its errors as a tree, `Errors`, relative to the value
//! it runs on. `field`, `optional_field`, `list` and `pairs` put their key
//! or index above the errors of a member only when it has errors, so a
//! decode that succeeds builds no path, and a step is stored once for all
//! the errors below it. `run` turns the tree into the list of `Error`s,
//! building each path once (D-901). The primitive decoders are a variant
//! of their own, `Leaf`, that `field` and `list` look into: they check a
//! value and take it without building a result and its errors.

// The module has functions named `float`, `int`, `list` and `string`, so it
// imports those modules under other names (§7.5.1, D-062).
import std::float as floats
import std::int as ints
import std::json::tree
import std::list as lists
import std::string as strings

/// A decoder of a `T` (D-320). It is opaque: its representation is not part
/// of the API.
pub type Decoder<T> {
  /// Decodes a value, giving the result or placeholder and the errors
  /// below that value.
  Decoder(fn(tree::Tree) -> (T, Errors)),
  /// A primitive decoder: what it expects, its placeholder, whether it
  /// accepts a value, and the result for a value it accepts. `json::value`
  /// is one too (D-1087).
  Leaf(String, T, fn(tree::Tree) -> Bool, fn(tree::Tree) -> T),
  /// A decoder made when it decodes a value: the placeholder where no value
  /// is decoded, and the function that makes the decoder (D-1086).
  Lazy(T, fn() -> Decoder<T>),
}

/// One value that did not fit (D-322, D-323): what the decoder `expected`,
/// the kind of JSON value `found` there, and the `path` from the decoded
/// value to it.
pub exposed type Error {
  expected: String,
  found: String,
  path: List<String>,
}

/// The errors a decoder recorded below the value it ran on, in the order
/// visited. No `Under` or `Both` holds `NoErrors`, so a decode without
/// errors gives exactly `NoErrors`. It is package-visible rather than
/// `priv` because the hidden fields of `Decoder` name it (D-198).
type Errors {
  NoErrors,
  /// A value that did not fit, at the value itself: what was expected and
  /// the kind of value found.
  Mismatch(String, String),
  /// The errors below the member or element named by the step.
  Under(String, Errors),
  /// The first errors, then the later ones.
  Both(Errors, Errors),
}

/// The errors still to flatten after the current ones, each with the path
/// of the value they are relative to.
priv type Pending {
  Done,
  Next(Errors, List<String>, Pending),
}

/// Decodes `value` for `json::parse` and `json::decode_value`: the decoded
/// value, or every error in the order visited, each recorded once (D-322,
/// D-404). Paths start at `value` itself.
fn run<T>(decoder: Decoder<T>, value: tree::Tree) -> Result<T, List<Error>> {
  let (decoded, errors) = apply(decoder, value)
  case errors {
    NoErrors => Ok(decoded)
    _ => Err(lists::unique(flatten(Next(errors, [], Done), [])))
  }
}

/// Adds the errors of `pending` to `out` in order, each with its whole
/// path. It keeps the errors still to visit in `pending` rather than on
/// the stack, so a tree of any depth is flattened (D-326).
priv fn flatten(pending: Pending, out: List<Error>) -> List<Error> {
  case pending {
    Done => out
    Next(NoErrors, _, rest) => flatten(rest, out)
    Next(Mismatch(expected, found), path, rest) => {
      let error = Error { expected, found, path }
      flatten(rest, lists::push(out, error))
    }
    Next(Under(step, inner), path, rest) => flatten(Next(inner, lists::push(path, step), rest), out)
    Next(Both(first, later), path, rest) => flatten(Next(first, path, Next(later, path, rest)), out)
  }
}

/// Runs `decoder` on `value`, giving its value or placeholder and the
/// errors it recorded below `value`.
priv fn apply<T>(decoder: Decoder<T>, value: tree::Tree) -> (T, Errors) {
  case decoder {
    Decoder(decode_tree) => decode_tree(value)
    Leaf(expected, placeholder, accepts, take) => case accepts(value) {
      True => (take(value), NoErrors)
      False => (placeholder, mismatch(expected, value))
    }
    Lazy(_, make) => apply(make(), value)
  }
}

/// The error of a value of the wrong kind, at the value itself.
priv fn mismatch(expected: String, value: tree::Tree) -> Errors {
  Mismatch(expected, tree::kind(value))
}

/// The error of the member or element `value`, named by `step`, of the
/// wrong kind.
priv fn mismatch_at(expected: String, value: tree::Tree, step: String) -> Errors {
  Under(step, Mismatch(expected, tree::kind(value)))
}

/// The errors `first`, then the errors `later`.
priv fn both(first: Errors, later: Errors) -> Errors {
  case first, later {
    NoErrors, _ => later
    _, NoErrors => first
    _, _ => Both(first, later)
  }
}

/// Puts `errors` before the errors of `outcome`.
priv fn then_errors<T>(errors: Errors, outcome: (T, Errors)) -> (T, Errors) {
  let (decoded, later) = outcome
  (decoded, both(errors, later))
}

// Primitive decoders

/// Decodes a JSON string. The placeholder is `""`.
pub fn string() -> Decoder<String> {
  Leaf("String", "", is_string, take_string)
}

priv fn is_string(value: tree::Tree) -> Bool {
  case value {
    tree::String(_) => True
    _ => False
  }
}

priv fn take_string(value: tree::Tree) -> String {
  case value {
    tree::String(text) => text
    _ => ""
  }
}

/// Decodes a JSON number read as an `Int`, never a `Float` (D-217, D-222).
/// The placeholder is `0`.
pub fn int() -> Decoder<Int> {
  Leaf("Int", 0, is_int, take_int)
}

priv fn is_int(value: tree::Tree) -> Bool {
  case value {
    tree::Int(_) => True
    _ => False
  }
}

priv fn take_int(value: tree::Tree) -> Int {
  case value {
    tree::Int(n) => n
    _ => 0
  }
}

/// Decodes any JSON number as a `Float`, converting an `Int` to the nearest
/// one (D-402). The placeholder is `0.0`.
pub fn float() -> Decoder<Float> {
  Leaf("Float", 0.0, is_number, take_float)
}

priv fn is_number(value: tree::Tree) -> Bool {
  case value {
    tree::Float(_) | tree::Int(_) => True
    _ => False
  }
}

priv fn take_float(value: tree::Tree) -> Float {
  case value {
    tree::Float(x) => x
    tree::Int(n) => floats::from_int(n)
    _ => 0.0
  }
}

/// Decodes `true` or `false`. The placeholder is `False`.
pub fn bool() -> Decoder<Bool> {
  Leaf("Bool", False, is_bool, take_bool)
}

priv fn is_bool(value: tree::Tree) -> Bool {
  case value {
    tree::Bool(_) => True
    _ => False
  }
}

priv fn take_bool(value: tree::Tree) -> Bool {
  case value {
    tree::Bool(flag) => flag
    _ => False
  }
}

// Arrays, objects and null

/// Decodes a JSON array, running `decoder` on each element in order, with
/// the element's index added to its errors' paths. The placeholder is `[]`.
pub fn list<T>(decoder: Decoder<T>) -> Decoder<List<T>> {
  Decoder(fn(value) {
    case value {
      tree::Array(items) => decode_items(items, decoder, 0, [], NoErrors)
      _ => ([], mismatch("Array", value))
    }
  })
}

/// Decodes `rest`, the elements from `index` on. `done` holds what the
/// earlier elements decoded to, and `found` holds their errors.
priv fn decode_items<T>(
  rest: List<tree::Tree>,
  decoder: Decoder<T>,
  index: Int,
  done: List<T>,
  found: Errors,
) -> (List<T>, Errors) {
  case rest {
    [] => (done, found)
    [item, ..tail] => case decoder {
      Leaf(expected, placeholder, accepts, take) => case accepts(item) {
        True => decode_items(tail, decoder, index + 1, [..done, take(item)], found)
        False => {
          let more = both(found, mismatch_at(expected, item, ints::show(index)))
          decode_items(tail, decoder, index + 1, [..done, placeholder], more)
        }
      }
      Decoder(decode_tree) => {
        let (element, element_errors) = decode_tree(item)
        let more = case element_errors {
          NoErrors => found
          _ => both(found, Under(ints::show(index), element_errors))
        }
        decode_items(tail, decoder, index + 1, [..done, element], more)
      }
      Lazy(_, make) => {
        let (element, element_errors) = apply(make(), item)
        let more = case element_errors {
          NoErrors => found
          _ => both(found, Under(ints::show(index), element_errors))
        }
        decode_items(tail, decoder, index + 1, [..done, element], more)
      }
    }
  }
}

/// Decodes `null` as `None`, and any other value as `Some` of what `decoder`
/// gives for it. Its placeholder is `Some` of `decoder`'s (D-401).
pub fn optional<T>(decoder: Decoder<T>) -> Decoder<Option<T>> {
  Decoder(fn(value) {
    case value {
      tree::Null => (None, NoErrors)
      _ => {
        let (decoded, errors) = apply(decoder, value)
        (Some(decoded), errors)
      }
    }
  })
}

/// Decodes a JSON object with any keys as its members in the order written,
/// repeated keys included, with `decoder` run on each value (D-403). The
/// placeholder is `[]`.
pub fn pairs<T>(decoder: Decoder<T>) -> Decoder<List<(String, T)>> {
  Decoder(fn(value) {
    case value {
      tree::Object(members) => {
        lists::fold(members, ([], NoErrors), fn((done, found), (key, member)) {
          let (element, element_errors) = apply(decoder, member)
          let more = case element_errors {
            NoErrors => found
            _ => both(found, Under(key, element_errors))
          }
          (lists::push(done, (key, element)), more)
        })
      }
      _ => ([], mismatch("Object", value))
    }
  })
}

/// Decodes the last member `name` of a JSON object with `decoder` (D-223),
/// then decodes the same object with the decoder `next` returns.
pub fn field<T, U>(name: String, decoder: Decoder<T>, next: fn(T) -> Decoder<U>) -> Decoder<U> {
  Decoder(fn(value) {
    case value {
      tree::Object(members) => find_field(members, name, decoder, next, value)
      _ => {
        let wrong = mismatch("Object", value)
        let after = next(missing_placeholder(decoder))
        then_errors(wrong, apply(after, value))
      }
    }
  })
}

/// Finishes `field` on the object `value`: looks for the last member `name`
/// in `rest`, searching from the end (D-223), decodes it and runs `next`.
priv fn find_field<T, U>(
  rest: List<(String, tree::Tree)>,
  name: String,
  decoder: Decoder<T>,
  next: fn(T) -> Decoder<U>,
  value: tree::Tree,
) -> (U, Errors) {
  case rest {
    [] => {
      let missing = Under(name, Mismatch("Field", "Nothing"))
      let after = next(missing_placeholder(decoder))
      then_errors(missing, apply(after, value))
    }
    [.., (key, member)] when key == name => case decoder {
      Leaf(expected, placeholder, accepts, take) => case accepts(member) {
        True => apply(next(take(member)), value)
        False => then_errors(mismatch_at(expected, member, name), apply(next(placeholder), value))
      }
      Decoder(decode_tree) => {
        let (decoded, errors) = decode_tree(member)
        case errors {
          NoErrors => apply(next(decoded), value)
          _ => then_errors(Under(name, errors), apply(next(decoded), value))
        }
      }
      Lazy(_, make) => {
        let (decoded, errors) = apply(make(), member)
        case errors {
          NoErrors => apply(next(decoded), value)
          _ => then_errors(Under(name, errors), apply(next(decoded), value))
        }
      }
    }
    [..front, _] => find_field(front, name, decoder, next, value)
  }
}

/// The placeholder for a field that is missing: what `decoder` gives for
/// `null`, with its errors dropped (D-401). A primitive decoder accepts no
/// `null`, so it gives its placeholder, and a `lazy` decoder gives its own
/// without making its decoder, so a recursive decoder never recurses here
/// (D-1086).
priv fn missing_placeholder<T>(decoder: Decoder<T>) -> T {
  case decoder {
    Leaf(_, placeholder, _, _) => placeholder
    Lazy(placeholder, _) => placeholder
    Decoder(decode_tree) => {
      let (placeholder, _) = decode_tree(tree::Null)
      placeholder
    }
  }
}

/// Like `field`, but a missing member `name` gives `default` and no error.
/// A present member is decoded by `decoder`, even when it is `null`.
pub fn optional_field<T, U>(
  name: String,
  default: T,
  decoder: Decoder<T>,
  next: fn(T) -> Decoder<U>,
) -> Decoder<U> {
  Decoder(fn(value) {
    // For a value that is not an object, `next` gets `default`, since
    // such a value has no member `name` (D-485).
    case value {
      tree::Object(members) => find_optional(members, name, default, decoder, next, value)
      _ => then_errors(mismatch("Object", value), apply(next(default), value))
    }
  })
}

/// Finishes `optional_field` on the object `value`, as `find_field` does
/// for `field`, with `default` for a missing member.
priv fn find_optional<T, U>(
  rest: List<(String, tree::Tree)>,
  name: String,
  default: T,
  decoder: Decoder<T>,
  next: fn(T) -> Decoder<U>,
  value: tree::Tree,
) -> (U, Errors) {
  case rest {
    [] => apply(next(default), value)
    [.., (key, member)] when key == name => {
      let (decoded, errors) = apply(decoder, member)
      case errors {
        NoErrors => apply(next(decoded), value)
        _ => then_errors(Under(name, errors), apply(next(decoded), value))
      }
    }
    [..front, _] => find_optional(front, name, default, decoder, next, value)
  }
}

// Combining decoders

/// Decodes the value with `decoder`, then decodes the same value with the
/// decoder `next` returns. When `decoder` fails, only its errors are
/// reported (D-405).
pub fn then<T, U>(decoder: Decoder<T>, next: fn(T) -> Decoder<U>) -> Decoder<U> {
  Decoder(fn(value) {
    let (decoded, errors) = apply(decoder, value)
    let (next_value, next_errors) = apply(next(decoded), value)
    case errors {
      NoErrors => (next_value, next_errors)
      _ => (next_value, errors)
    }
  })
}

/// Decodes the value with `decoder` and applies `f` to the result, or to the
/// placeholder when `decoder` fails (D-403).
pub fn map<T, U>(decoder: Decoder<T>, f: fn(T) -> U) -> Decoder<U> {
  Decoder(fn(value) {
    let (decoded, errors) = apply(decoder, value)
    (f(decoded), errors)
  })
}

/// Runs `first` and then each decoder of `others`, in order, on the same
/// value, and gives the result of the first one that records no errors.
/// When every one fails, it gives `first`'s result and errors (D-1088).
pub fn one_of<T>(first: Decoder<T>, others: List<Decoder<T>>) -> Decoder<T> {
  Decoder(fn(value) {
    let outcome = apply(first, value)
    case outcome {
      (_, NoErrors) => outcome
      _ => first_fit(others, value, outcome)
    }
  })
}

/// Finishes `one_of`: the outcome of the first decoder of `rest` that
/// records no errors on `value`, or `fallback`, `first`'s outcome.
priv fn first_fit<T>(
  rest: List<Decoder<T>>,
  value: tree::Tree,
  fallback: (T, Errors),
) -> (T, Errors) {
  case rest {
    [] => fallback
    [decoder, ..tail] => {
      let outcome = apply(decoder, value)
      case outcome {
        (_, NoErrors) => outcome
        _ => first_fit(tail, value, fallback)
      }
    }
  }
}

/// Decodes the member reached through the object keys of `path` with
/// `decoder`, as nested `field` calls do, and `at([], decoder)` is
/// `decoder` (D-1088).
pub fn at<T>(path: List<String>, decoder: Decoder<T>) -> Decoder<T> {
  case path {
    [] => decoder
    [name, ..rest] => field(name, at(rest, decoder), success)
  }
}

/// A decoder that calls `make` each time it decodes a value and decodes the
/// value with the decoder `make` returns. Where no value is decoded, for a
/// missing field and for a value that is not an object, it gives
/// `placeholder` without calling `make`, so a decoder that refers to itself
/// is built in O(1) and its placeholder never recurses (D-1086).
pub fn lazy<T>(placeholder: T, make: fn() -> Decoder<T>) -> Decoder<T> {
  Lazy(placeholder, make)
}

/// A decoder that ignores the value and gives `value`.
pub fn success<T>(value: T) -> Decoder<T> {
  Decoder(fn(_) { (value, NoErrors) })
}

/// A decoder that always fails with `expected` and goes on with
/// `placeholder` (D-322).
pub fn failure<T>(placeholder: T, expected: String) -> Decoder<T> {
  Decoder(fn(value) { (placeholder, mismatch(expected, value)) })
}

// Errors

/// Writes `expected E, found F`, then `at` and the path's elements separated
/// by `.` when the path is not empty (D-400). It makes `Error` satisfy
/// `Show`.
pub fn show(error: Error) -> String {
  let message = "expected {error.expected}, found {error.found}"
  case error.path {
    [] => message
    steps => {
      let joined = strings::join(steps, ".")
      "{message} at {joined}"
    }
  }
}

test "a decode error shows what was expected, found and where" {
  let nested = Error { expected: "Format", found: "String", path: ["books", "1", "format"] }
  assert show(nested) == "expected Format, found String at books.1.format"
  let top = Error { expected: "Array", found: "Null", path: [] }
  assert "{top}" == "expected Array, found Null"
}

test "a decode error's path is joined with dots, empty keys included" {
  let empty_key = Error { expected: "Array", found: "Int", path: [""] }
  assert show(empty_key) == "expected Array, found Int at "
  let dotted = Error { expected: "Int", found: "Bool", path: ["a.b", "0", ""] }
  assert show(dotted) == "expected Int, found Bool at a.b.0."
}
