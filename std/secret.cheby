//! `Secret<T>`, a value that never appears in printed text (D-1901).
//!
//! A secret holds one value and prints as `<redacted>` wherever text is
//! made of it, with `Show` and with debug printing, alone or inside another
//! value (D-1902, D-1903). Only `expose` and the function given to `map`
//! see the value (D-1905).
//!
//! The module has no kernels and imports nothing, so it runs in constants
//! and on JS unchanged (D-1901, D-1906).

/// A value that never appears in printed text (D-1901). Equality, hashing
/// and debug printing go through `equal`, `hash` and `debug` (D-342): two
/// secrets are `==` when their values are, and a secret's debug text is
/// `<redacted>` (D-1902, D-1904). It satisfies `Show` through `show`.
@std_hooks(equal, hash, debug)
pub type Secret<T> {
  Secret(T),
}

/// Whether two secrets hold values that are `==`. The comparison stops at
/// the first difference, so it is not constant-time (D-1904).
fn equal<T>(a: Secret<T>, b: Secret<T>) -> Bool {
  expose(a) == expose(b)
}

/// What two equal secrets share, which the runtime hashes: the value
/// (D-1904).
fn hash<T>(s: Secret<T>) -> T {
  expose(s)
}

/// The debug text of a secret, the text of `show` (D-1902).
fn debug<T>(s: Secret<T>) -> String {
  show(s)
}

/// A record with a secret field, for the tests.
priv type Login {
  user: String,
  password: Secret<String>,
}

test "a secret field prints as <redacted>" {
  let login = Login { user: "ada", password: new("hunter2") }
  assert "{login:?}" == "Login \{ user: \"ada\", password: <redacted> }"
}

test "a secret prints as <redacted> inside other values" {
  let found = Some(new("hunter2"))
  let several = [new(1), new(2)]
  let pair = (new("a"), 1)
  let nested = new(new("hunter2"))
  assert "{found:?}" == "Some(<redacted>)"
  assert "{several:?}" == "[<redacted>, <redacted>]"
  assert "{pair:?}" == "(<redacted>, 1)"
  assert "{nested:?}" == "<redacted>"
}

test "secrets compare by their values" {
  assert new("hunter2") == new("hunter2")
  assert new("hunter2") != new("hunter3")
  let login = Login { user: "ada", password: new("hunter2") }
  assert login == Login { user: "ada", password: new("hunter2") }
  assert login != Login { user: "ada", password: new("other") }
}

// Functions

/// Returns a secret that holds `value`. It works in constants, and the
/// value of a constant is in the executable and in the build cache, as
/// every literal is (D-1906).
pub fn new<T>(value: T) -> Secret<T> {
  Secret(value)
}

test "new hides a value of any type" {
  assert expose(new("hunter2")) == "hunter2"
  assert expose(new(1234)) == 1234
  let pin = new(1234)
  assert "{pin:?}" == "<redacted>"
}

/// Returns the value that `s` holds. Only `expose` and the function given
/// to `map` see it, so a search for the two names finds every place that
/// reads a secret (D-1905). What it returns prints as any value does.
pub fn expose<T>(s: Secret<T>) -> T {
  let Secret(value) = s
  value
}

test "expose returns the value" {
  let token = new("hunter2")
  let text = expose(token)
  assert text == "hunter2"
  assert "{text:?}" == "\"hunter2\""
}

/// Returns a secret that holds `f` of the value that `s` holds, so the
/// result is as hidden as `s` is (D-1905).
pub fn map<T, U>(s: Secret<T>, f: fn(T) -> U) -> Secret<U> {
  Secret(f(expose(s)))
}

test "map keeps the result hidden" {
  let words = map(new("hunter2"), fn(token) { ["Bearer", token] })
  assert "{words}" == "<redacted>"
  assert expose(words) == ["Bearer", "hunter2"]
}

/// Returns `<redacted>`, whatever `s` holds. It makes `Secret` satisfy
/// `Show` (§8.8) for every `T`, also one that does not (D-1903).
pub fn show<T>(s: Secret<T>) -> String {
  let _ = s
  "<redacted>"
}

test "show hides the value" {
  let token = new("hunter2")
  assert show(token) == "<redacted>"
  assert "{token}" == "<redacted>"
  assert "Bearer {token}" == "Bearer <redacted>"
}

test "show needs no Show of the value" {
  let hidden = new(fn(x: Int) { x + 1 })
  assert show(hidden) == "<redacted>"
}
