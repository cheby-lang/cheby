//! Typed, bounded channels between fibers (§10.5, D-013, D-054).
//!
//! A channel is a FIFO queue with a capacity, reached through a `Sender`
//! and a `Receiver`. Both are handles: external types whose drop
//! functions the runtime supplies (D-101, D-647, D-703). A channel closes
//! for its receivers when its last `Sender` is dropped, and for its
//! senders when its last `Receiver` is dropped, and the drop functions
//! never block or suspend (D-087, D-205, D-672). The last `Receiver`
//! releases the values still buffered (D-670). A sent value becomes shared
//! (§9.4, D-072).
//!
//! `new`, `send` and `receive` are kernels that receive the running
//! fiber's context (D-692), and `send_now` and `receive_now` are written
//! over two more, which never wait (D-1099). Each kernel also declares its
//! JS binding, written with the JS back end (D-661). The tests of this module that need
//! `std::fiber` live there, because `std::fiber` imports this module
//! (D-630).

// Handles

/// The sending end of a channel of `T` values. It prints as `<Sender>`,
/// and `==` and hashing panic when they reach one (D-233, D-647).
pub type Sender<T>

/// The receiving end of a channel of `T` values. It prints as
/// `<Receiver>`, and `==` and hashing panic when they reach one (D-233,
/// D-647).
pub type Receiver<T>

// Building

/// Returns the two ends of a new channel that buffers up to `capacity`
/// values. Capacity 0 is a synchronous handoff: a send completes only when
/// a receiver takes the value (D-054). A negative capacity counts as 0
/// (D-298, D-672). The buffer's memory grows with the values it holds, not
/// with `capacity`.
@std_context
@external(native, "cheby_channel_new")
@external(js, "./channel.mjs", "new")
@std_clamped(capacity)
pub fn new<T>(capacity: Int) -> (Sender<T>, Receiver<T>)

test "a channel delivers values in the order they were sent" {
  let (tx, rx) = new::<Int>(2)
  let assert Ok(Nil) = send(tx, 1)
  let assert Ok(Nil) = send(tx, 2)
  assert receive(rx) == Ok(1)
  assert receive(rx) == Ok(2)
  assert receive(rx) == Err(Nil)
}

test "handles print as placeholders" {
  let (tx, rx) = new::<Int>(0)
  assert "{tx:?} {rx:?}" == "<Sender> <Receiver>"
}

// Sending and receiving

/// Puts `value` into the channel and returns `Ok(Nil)` once it is
/// enqueued, or, for capacity 0, once a receiver has taken it (§10.5.1,
/// D-087, D-179, D-206). While the buffer is full, or for capacity 0
/// while nobody takes the value, the calling fiber waits. Returns
/// `Err(value)` when every `Receiver` has been dropped, before the call or
/// while the fiber waited. A cancelled `send` has not enqueued `value`
/// (D-102, D-670).
@std_context
@external(native, "cheby_channel_send")
@external(js, "./channel.mjs", "send")
pub fn send<T>(sender: Sender<T>, value: T) -> Result<Nil, T>

test "send gives the value back once every Receiver is gone" {
  let (tx, _) = new::<String>(4)
  assert send(tx, "lost") == Err("lost")
}

/// Takes the next value from the channel and returns it in `Ok` (§10.5.2,
/// D-054, D-179). While the channel is empty and some `Sender` still
/// exists, the calling fiber waits. Values buffered before the last
/// `Sender` was dropped are still received; then it returns `Err(Nil)`. A
/// cancelled `receive` takes nothing (D-670).
@std_context
@external(native, "cheby_channel_receive")
@external(js, "./channel.mjs", "receive")
pub fn receive<T>(receiver: Receiver<T>) -> Result<T, Nil>

test "receive drains the buffer before it reports the closing" {
  let (tx, rx) = new::<String>(2)
  let assert Ok(Nil) = send(tx, "last words")
  // `tx` is not used again, so the channel is closed now.
  assert receive(rx) == Ok("last words")
  assert receive(rx) == Err(Nil)
}

test "values still buffered are released with the last Receiver" {
  let (inner_tx, inner_rx) = new::<Int>(0)
  let (spare_tx, _) = new::<Int>(0)
  let (tx, rx) = new::<Sender<Int>>(1)
  let assert Ok(Nil) = send(tx, inner_tx)
  // Dropping the only `Receiver` releases the buffered `inner_tx`,
  // although `tx` is still alive.
  let _ = rx
  assert receive(inner_rx) == Err(Nil)
  let assert Err(_) = send(tx, spare_tx)
}

// Not waiting

/// Why `send_now` did not send, with the value given back either way
/// (D-179, D-1099). `Full(value)`: the buffer had no room, or, for capacity
/// 0, no receiver or selector was waiting. `Closed(value)`: every
/// `Receiver` is gone.
pub exposed type Refused<T> {
  Full(T),
  Closed(T),
}

/// `send` without the wait: 0 when `value` was enqueued or handed to a
/// receiver or a selector that was waiting, 1 when it could not be, and 2
/// when every `Receiver` is gone, which is checked first (D-1099).
@std_context
@external(native, "cheby_channel_sys_send_now")
@external(js, "./channel.mjs", "sys_send_now")
fn sys_send_now<T>(sender: Sender<T>, value: T) -> Int

/// Enqueues `value` and returns `Ok(Nil)` when the buffer has room, or
/// hands it to a receiver or a selector that is waiting now (D-1099). On
/// capacity 0 it succeeds only when it wins a waiting receiver or selector,
/// as `send` claims one (D-206), and it never waits for a selector's
/// choice. It returns `Err(Closed(value))` when every `Receiver` is gone,
/// which is checked first, and `Err(Full(value))` otherwise. It never waits
/// and is not a suspension point (§10.5, D-185).
pub fn send_now<T>(sender: Sender<T>, value: T) -> Result<Nil, Refused<T>> {
  case sys_send_now(sender, value) {
    0 => Ok(Nil)
    1 => Err(Full(value))
    _ => Err(Closed(value))
  }
}

test "send_now reports a full buffer and gives the value back" {
  let (tx, rx) = new::<Int>(1)
  assert send_now(tx, 1) == Ok(Nil)
  assert send_now(tx, 2) == Err(Full(2))
  assert receive_now(rx) == Some(Ok(1))
  assert send_now(tx, 3) == Ok(Nil)
  assert receive_now(rx) == Some(Ok(3))
}

test "send_now without receivers is Closed" {
  let (tx, _) = new::<Int>(0)
  assert send_now(tx, 3) == Err(Closed(3))
}

/// `receive` without the wait: `Some` of what `receive` would return when
/// it would not wait, and `None` otherwise (D-1099).
@std_context
@external(native, "cheby_channel_sys_receive_now")
@external(js, "./channel.mjs", "sys_receive_now")
fn sys_receive_now<T>(receiver: Receiver<T>) -> Option<Result<T, Nil>>

/// Returns `Some` of what `receive` would return when `receive` would not
/// wait, and `None` otherwise (D-1099). So `Some(Ok(value))` takes the next
/// value, from the buffer or from a sender waiting on a capacity-0 channel,
/// `Some(Err(Nil))` means that the channel is closed and empty, and `None`
/// that it is empty and some `Sender` still exists. It never waits and is
/// not a suspension point (§10.5, D-185).
pub fn receive_now<T>(receiver: Receiver<T>) -> Option<Result<T, Nil>> {
  sys_receive_now(receiver)
}

test "receive_now never waits" {
  let (tx, rx) = new::<String>(1)
  assert receive_now(rx) == None
  let assert Ok(Nil) = send(tx, "ready")
  assert receive_now(rx) == Some(Ok("ready"))
  // `tx` is not used again, so the channel is closed and empty now.
  assert receive_now(rx) == Some(Err(Nil))
}

// Draining and filling

/// Receives until the channel is closed and empty, and folds each value
/// into the accumulator in the order received, as `list::fold` does
/// (D-1100). It calls `f` on the calling fiber, so a tail call to it keeps
/// its tail call (D-1059).
pub fn fold<T, A>(receiver: Receiver<T>, initial: A, f: fn(A, T) -> A) -> A {
  case receive(receiver) {
    Ok(value) => fold(receiver, f(initial, value), f)
    Err(Nil) => initial
  }
}

test "fold receives until the channel is closed" {
  let (tx, rx) = new::<Int>(3)
  let assert Ok(Nil) = send(tx, 1)
  let assert Ok(Nil) = send(tx, 2)
  let assert Ok(Nil) = send(tx, 3)
  // `tx` is not used again, so the channel is closed now.
  assert fold(rx, [], fn(seen, n) { [n, ..seen] }) == [3, 2, 1]
}

/// Receives and folds as `fold` does, but `f` returns a `Result`: the
/// first `Err` stops it and is returned, and the values still in the
/// channel stay there. Otherwise it returns `Ok` of the last accumulator
/// (D-1080, D-1100).
pub fn try_fold<T, A, E>(
  receiver: Receiver<T>,
  initial: A,
  f: fn(A, T) -> Result<A, E>,
) -> Result<A, E> {
  case receive(receiver) {
    Ok(value) => case f(initial, value) {
      Ok(next) => try_fold(receiver, next, f)
      Err(error) => Err(error)
    }
    Err(Nil) => Ok(initial)
  }
}

test "try_fold stops at the first Err and leaves the rest" {
  let (tx, rx) = new::<Int>(4)
  let assert Ok(Nil) = send_all(tx, [1, 2, -3, 4])
  let total = try_fold(rx, 0, fn(sum, n) {
    case n < 0 {
      True => Err(n)
      False => Ok(sum + n)
    }
  })
  assert total == Err(-3)
  assert receive(rx) == Ok(4)
  assert receive(rx) == Err(Nil)
}

test "try_fold of a closed channel is Ok of the last accumulator" {
  let (tx, rx) = new::<Int>(2)
  let assert Ok(Nil) = send_all(tx, [5, 6])
  let total: Result<Int, Nil> = try_fold(rx, 0, fn(sum, n) { Ok(sum + n) })
  assert total == Ok(11)
}

/// Returns every value received until the channel is closed and empty, in
/// the order received (D-1100). It calls no function value, so a tail call
/// to it keeps its caller's frame (D-1059).
pub fn to_list<T>(receiver: Receiver<T>) -> List<T> {
  receive_into(receiver, [])
}

/// `received` followed by every value received until the channel is
/// closed and empty.
fn receive_into<T>(receiver: Receiver<T>, received: List<T>) -> List<T> {
  case receive(receiver) {
    Ok(value) => receive_into(receiver, [..received, value])
    Err(Nil) => received
  }
}

test "to_list drains a closed channel" {
  let (tx, rx) = new::<String>(2)
  let assert Ok(Nil) = send_all(tx, ["a", "b"])
  assert to_list(rx) == ["a", "b"]
}

/// Sends the elements of `xs` in order and returns `Ok(Nil)`, or, once
/// every `Receiver` is gone, `Err` with the elements it could not send,
/// starting with the refused one (D-179, D-1100). It calls no function
/// value, so a tail call to it keeps its caller's frame (D-1059).
pub fn send_all<T>(sender: Sender<T>, xs: List<T>) -> Result<Nil, List<T>> {
  case xs {
    [] => Ok(Nil)
    [first, ..rest] => case send(sender, first) {
      Ok(Nil) => send_all(sender, rest)
      Err(refused) => Err([refused, ..rest])
    }
  }
}

test "send_all gives back what it could not send" {
  let (tx, _) = new::<Int>(4)
  assert send_all(tx, [1, 2, 3]) == Err([1, 2, 3])
  assert send_all(tx, []) == Ok(Nil)
}
