//! Draws the Mandelbrot set as ASCII art.
//!
//! A complex number `c` is in the Mandelbrot set when repeating
//! `z = z * z + c`, starting from `z = 0`, never takes `z` further than
//! 2 from zero. Each character of the picture stands for one point.
//! Points that are still close to zero after `max_iterations` steps
//! count as inside and are drawn as `@`. The other points are shaded
//! by how many steps they took to escape, from ` ` (at once) to `%`
//! (almost never).
//!
//! The whole picture is a compile-time constant, so the program only
//! prints it.

import std::io
import std::list
import std::ops

import mandelbrot::complex

/// The number of characters in each row.
const width: Int = 60

/// The number of rows.
const height: Int = 24

/// How many steps a point may take before it counts as inside.
const max_iterations: Int = 50

/// The real part of the leftmost column.
const left: Float = -2.0

/// The imaginary part of the top row.
const top: Float = 1.15

/// The distance between neighboring columns.
const column_step: Float = 0.05

/// The distance between neighboring rows. It is twice `column_step`
/// because a character is about twice as tall as it is wide.
const row_step: Float = 0.1

/// The rendered picture, one string per row. The compiler evaluates
/// the call to `render` while building, so it is never computed at
/// run time.
const picture: List<String> = render()

fn main() {
  let corner = complex::new(left, top)
  io::println("The Mandelbrot set, with {corner} at the top left:")
  list::each(picture, io::println)
}

/// Returns the rows of the picture, from top to bottom.
fn render() -> List<String> {
  fn step(im, remaining, rows) {
    case remaining {
      0 => rows
      _ => step(im - row_step, remaining - 1, [..rows, render_row(left, im, width)])
    }
  }
  step(top, height, [])
}

/// Returns `count` characters for the points on the row with
/// imaginary part `im`, starting at real part `re` and moving right.
fn render_row(re: Float, im: Float, count: Int) -> String {
  // Numbers are never converted implicitly, so instead of turning a
  // column number into a `Float`, the real part itself is carried
  // along and advanced by `column_step` each time.
  fn step(point_re, remaining, text) {
    case remaining {
      0 => text
      _ => {
        let character = shade(escape_time(complex::new(point_re, im)))
        step(point_re + column_step, remaining - 1, text + character)
      }
    }
  }
  step(re, count, "")
}

/// Returns how many steps it takes the point `c` to get further than 2
/// from zero, or `None` if it has not after `max_iterations` steps.
fn escape_time(c: complex::Complex) -> Option<Int> {
  fn step(z, steps) {
    case {
      steps == max_iterations => None
      // Comparing squares avoids a square root: `z` is further than 2
      // from zero exactly when its squared distance is more than 4.
      complex::magnitude_squared(z) > 4.0 => Some(steps)
      // `square(z) + c` is the same as `z * z + c`. The `+` resolves
      // to `complex::add`, because `Complex` is declared in the
      // `complex` module. No import of `std::ops` is needed for that.
      _ => step(square(z) + c, steps + 1)
    }
  }
  step(complex::new(0.0, 0.0), 0)
}

/// Multiplies `x` by itself, for any type that satisfies `Mul`.
/// Naming the interface in the bound is what needs `import std::ops`.
/// `Int` and `Float` satisfy `Mul` through `std::int` and
/// `std::float`, and `Complex` through `complex::mul`.
fn square<T: ops::Mul>(x: T) -> T {
  x * x
}

/// Picks the character for a point from its escape time. The faster a
/// point escapes, the lighter its character.
priv fn shade(escape: Option<Int>) -> String {
  case escape {
    None => "@"
    // `steps` is below `max_iterations`, so the band is 0 to 8.
    Some(steps) => case steps * 9 / max_iterations {
      0 => " "
      1 => "."
      2 => ":"
      3 => "-"
      4 => "="
      5 => "+"
      6 => "*"
      7 => "#"
      _ => "%"
    }
  }
}

test "square works for every type that satisfies Mul" {
  assert square(3) == 9
  assert square(1.5) == 2.25
  assert square(complex::new(0.0, 1.0)) == complex::new(-1.0, 0.0)
}

test "one step of the iteration is z * z + c" {
  let z = complex::new(1.0, 2.0)
  let c = complex::new(0.5, -0.5)
  assert square(z) + c == z * z + c
  assert z * z + c == complex::new(-2.5, 3.5)
}

test "points in the set never escape" {
  // 0, -i, -1 - i, i, -1 - i, i, ... keeps cycling.
  assert escape_time(complex::new(0.0, -1.0)) == None
  assert escape_time(complex::new(0.0, 0.0)) == None
  assert escape_time(complex::new(-1.0, 0.0)) == None
  assert escape_time(complex::new(-2.0, 0.0)) == None
}

test "points outside the set escape quickly" {
  // 0, then 2 + 2i, which is already further than 2 from zero.
  assert escape_time(complex::new(2.0, 2.0)) == Some(1)
  // 0, 1, 2, 5.
  assert escape_time(complex::new(1.0, 0.0)) == Some(3)
}

test "faster escapes get lighter characters" {
  assert shade(None) == "@"
  assert shade(Some(0)) == " "
  assert shade(Some(25)) == "="
  assert shade(Some(max_iterations - 1)) == "%"
}

test "a row shades each point along the real axis" {
  // 0.15, 0.2 and 0.25 are in the set. 0.3 escapes after 12 steps.
  assert render_row(0.15, 0.0, 4) == "@@@:"
}

test "the picture has height rows and a blank top row" {
  let assert [first, ..] = picture
  assert list::length(picture) == height
  assert first == "                                                            "
}
