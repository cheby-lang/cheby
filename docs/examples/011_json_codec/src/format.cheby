//! The ways a book is published, and how they are written as JSON.
//!
//! In JSON a format is a string: `"hardcover"`, `"paperback"` or
//! `"ebook"`.

import std::json
import std::json::decode

/// How a book is published.
///
/// The type is `pub exposed`: its three variants are all there is to it,
/// so other packages may build and match on them too. `Author` and `Book`
/// are only `pub`, which keeps their fields private to this package.
pub exposed type Format {
  Hardcover,
  Paperback,
  Ebook,
}

/// Makes `Format` satisfy `Show`, so a format can be interpolated. It
/// shows as the name used in JSON. It is `pub`, as visible as `Format`,
/// because a less visible `show` would not count.
pub fn show(format: Format) -> String {
  case format {
    Hardcover => "hardcover"
    Paperback => "paperback"
    Ebook => "ebook"
  }
}

// Generated by the "Generate JSON functions" code action from the
// declaration of `Format`. It is ordinary code, edited by hand. To
// start over, delete the functions and run the action again.
// Variants without fields are written as their names in snake_case.

/// Encodes `format` as a JSON string.
pub fn to_json(format: Format) -> json::Value {
  case format {
    Hardcover => json::String("hardcover")
    Paperback => json::String("paperback")
    Ebook => json::String("ebook")
  }
}

/// Decodes one of the strings that `to_json` writes. Any other string
/// fails with `expected: "Format"`.
pub fn decoder() -> decode::Decoder<Format> {
  // `decode::then` decodes a string and passes it to its last argument,
  // a callback that returns the decoder to use next. `use` writes that
  // callback as the rest of the block.
  use name <- decode::then(decode::string())
  case name {
    "hardcover" => decode::success(Hardcover)
    "paperback" => decode::success(Paperback)
    "ebook" => decode::success(Ebook)
    // The result is an error either way. `Hardcover` is only a
    // placeholder that lets decoding go on and find further errors.
    _ => decode::failure(Hardcover, "Format")
  }
}

test "formats show as their JSON names" {
  assert show(Hardcover) == "hardcover"
  assert show(Paperback) == "paperback"
  assert show(Ebook) == "ebook"
}

test "formats encode as strings" {
  assert json::to_string(to_json(Hardcover)) == r#""hardcover""#
  assert json::to_string(to_json(Paperback)) == r#""paperback""#
  assert json::to_string(to_json(Ebook)) == r#""ebook""#
}

test "decoding gives back every format" {
  assert json::parse(json::to_string(to_json(Hardcover)), decoder()) == Ok(Hardcover)
  assert json::parse(json::to_string(to_json(Paperback)), decoder()) == Ok(Paperback)
  assert json::parse(json::to_string(to_json(Ebook)), decoder()) == Ok(Ebook)
}

test "unknown names and other kinds of value are decode errors" {
  // The value is the whole document here, so the path is empty.
  let unknown = decode::Error { expected: "Format", found: "String", path: [] }
  assert json::parse(r#""audiobook""#, decoder()) == Err(json::Decode([unknown]))
  let not_a_string = decode::Error { expected: "String", found: "Int", path: [] }
  assert json::parse("3", decoder()) == Err(json::Decode([not_a_string]))
}
