//! A book, and how a book is written as JSON.
//!
//! `Book`, `Author` and `Format` each have a module of their own. Every
//! one of them has functions named `to_json` and `decoder`, and function
//! names in a module are unique, so one module can hold them for only one
//! type. The same rule means a module can satisfy an interface such as
//! `json::ToJson` for only one type (ADR-0020).

import std::json
import std::json::decode

import json_codec::author
import json_codec::format

/// A book in the library.
///
/// Like `author::Author`, the type is `pub` but not `exposed`, so its
/// fields are private to this package.
pub type Book {
  title: String,
  author: author::Author,
  published: Int,
  format: format::Format,
  tags: List<String>,
}

// Generated by the "Generate JSON functions" code action from the
// declaration of `Book`. It is ordinary code, edited by hand. To
// start over, delete the functions and run the action again.
// The generator names each JSON key after its field, and encodes and
// decodes the fields of other types with their own modules' `to_json`
// and `decoder`.

/// Encodes `book` as a JSON object, with the keys in field order.
///
/// It has the signature that `json::ToJson` requires, and it is `pub`,
/// as visible as `Book`, so `Book` satisfies `json::ToJson`. For a `pub`
/// type, a less visible function would not count.
pub fn to_json(book: Book) -> json::Value {
  json::Object([
    ("title", json::String(book.title)),
    ("author", author::to_json(book.author)),
    // Edited by hand: the generator wrote "published", but the files
    // this program reads call the year of publication "year".
    ("year", json::Int(book.published)),
    ("format", format::to_json(book.format)),
    ("tags", json::array(book.tags, json::String)),
  ])
}

/// Decodes an object with the keys that `to_json` writes. `tags` may be
/// left out, and then it is empty.
pub fn decoder() -> decode::Decoder<Book> {
  // Each `use` decodes one key and binds its value for the lines after
  // it. `author` and `format` are the names of imported modules, and
  // Cheby has no shadowing, so those two values need other names.
  use title <- decode::field("title", decode::string())
  use writer <- decode::field("author", author::decoder())
  // Edited by hand, to match the "year" key in `to_json`.
  use published <- decode::field("year", decode::int())
  use edition <- decode::field("format", format::decoder())
  use tags <- decode::optional_field("tags", [], decode::list(decode::string()))
  decode::success(Book { title, author: writer, published, format: edition, tags })
}

test "a book encodes as compact JSON and decodes back" {
  let dune = Book {
    title: "Dune",
    author: author::Author { name: "Frank Herbert", born: Some(1920) },
    published: 1965,
    format: format::Paperback,
    tags: ["science fiction", "classic"],
  }
  let expected =
    r#"{"title":"Dune","author":{"name":"Frank Herbert","born":1920},"year":1965,"format":"paperback","tags":["science fiction","classic"]}"#
  assert json::to_string(to_json(dune)) == expected
  assert json::parse(json::to_string(to_json(dune)), decoder()) == Ok(dune)
}

test "missing tags decode as an empty list" {
  let text =
    r#"{"title":"Beloved","author":{"name":"Toni Morrison"},"year":1987,"format":"hardcover"}"#
  let beloved = Book {
    title: "Beloved",
    author: author::Author { name: "Toni Morrison", born: None },
    published: 1987,
    format: format::Hardcover,
    tags: [],
  }
  assert json::parse(text, decoder()) == Ok(beloved)
}

test "a value of the wrong kind is a decode error at its path" {
  let year_text =
    r#"{"title":"Dune","author":{"name":"Frank Herbert"},"year":"1965","format":"ebook"}"#
  let year_problem = decode::Error { expected: "Int", found: "String", path: ["year"] }
  assert json::parse(year_text, decoder()) == Err(json::Decode([year_problem]))
  // A key of a nested object adds to the path.
  let name_text = r#"{"title":"Dune","author":{"name":42},"year":1965,"format":"ebook"}"#
  let name_problem = decode::Error { expected: "String", found: "Int", path: ["author", "name"] }
  assert json::parse(name_text, decoder()) == Err(json::Decode([name_problem]))
}

test "an unknown format is a decode error at the format" {
  let text =
    r#"{"title":"Dune","author":{"name":"Frank Herbert"},"year":1965,"format":"audiobook"}"#
  let problem = decode::Error { expected: "Format", found: "String", path: ["format"] }
  assert json::parse(text, decoder()) == Err(json::Decode([problem]))
}
