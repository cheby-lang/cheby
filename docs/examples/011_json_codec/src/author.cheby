//! The author of a book, and how an author is written as JSON.
//!
//! In JSON an author is an object such as
//! `{"name":"Frank Herbert","born":1920}`. When the year of birth is not
//! known, `born` may be `null` or left out.

import std::json
import std::json::decode

/// A book's author, with the year they were born if it is known.
///
/// The type is `pub` but not `exposed`: other packages can pass authors
/// around, but only this package can build them, match on them or read
/// their fields (ADR-0016). Everyone else goes through `to_json` and
/// `decoder`, so the fields can change without breaking other packages.
pub type Author {
  name: String,
  born: Option<Int>,
}

// Generated by the "Generate JSON functions" code action from the
// declaration of `Author`. It is ordinary code, edited by hand. To
// start over, delete the functions and run the action again.

/// Encodes `author` as a JSON object. An unknown year of birth is
/// written as `null`.
pub fn to_json(author: Author) -> json::Value {
  json::Object([
    ("name", json::String(author.name)),
    ("born", json::nullable(author.born, json::Int)),
  ])
}

/// Decodes an object with a string `name` and an optional whole-number
/// `born`.
pub fn decoder() -> decode::Decoder<Author> {
  // `decode::field` takes a callback as its last argument, so `use` can
  // write that callback as the rest of the block. `name` is bound to the
  // decoded field, and the lines after it return the decoder for the
  // rest of the object.
  use name <- decode::field("name", decode::string())
  // For an `Option` field the generator combines two helpers:
  // `optional_field` gives the default `None` when the key is missing,
  // and `optional` gives `None` when its value is `null`.
  use born <- decode::optional_field("born", None, decode::optional(decode::int()))
  decode::success(Author { name, born })
}

test "authors encode as objects, with null for an unknown year" {
  let herbert = Author { name: "Frank Herbert", born: Some(1920) }
  assert json::to_string(to_json(herbert)) == r#"{"name":"Frank Herbert","born":1920}"#
  let homer = Author { name: "Homer", born: None }
  assert json::to_string(to_json(homer)) == r#"{"name":"Homer","born":null}"#
}

test "decoding gives back the author that was encoded" {
  let herbert = Author { name: "Frank Herbert", born: Some(1920) }
  assert json::parse(json::to_string(to_json(herbert)), decoder()) == Ok(herbert)
}

test "a missing or null year of birth decodes as None" {
  let homer = Author { name: "Homer", born: None }
  assert json::parse(r#"{"name":"Homer"}"#, decoder()) == Ok(homer)
  assert json::parse(r#"{"name":"Homer","born":null}"#, decoder()) == Ok(homer)
}

test "a year of birth that is not a number is a decode error" {
  let problem = decode::Error { expected: "Int", found: "String", path: ["born"] }
  assert json::parse(r#"{"name":"Homer","born":"long ago"}"#, decoder()) == Err(json::Decode([
    problem,
  ]))
}
